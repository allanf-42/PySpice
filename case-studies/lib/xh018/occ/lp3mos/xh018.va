//xh018 Occ file v3.0 generated by E.Mueller (6642) on Mon Aug 16 13:12:47 2010

`include "discipline.h"
`include "constants.h"

// Verilog-A OC Watch for device ne Parameters  VGS VGD VDS VDB VSB
module ne_ahdl(D,G,S,B);
parameter tstep_occ=100n;
inout D,G,S,B;
electrical D,G,S,B;

integer outfile;
real V_S_B;
real V_D_B;
real V_D_S;
real V_G_D;
real V_G_S;
real VGS;
integer VGS_retc;
real VGD;
integer VGD_retc;
real VDS;
integer VDS_retc;
real VDB;
integer VDB_retc;
real VSB;
integer VSB_retc;

analog begin

   $bound_step( tstep_occ );
   @(initial_step) begin
      VGS_retc=0;
      VGD_retc=0;
      VDS_retc=0;
      VDB_retc=0;
      VSB_retc=0;
   end
   V_S_B = V(S,B);
   V_D_B = V(D,B);
   V_D_S = V(D,S);
   V_G_D = V(G,D);
   V_G_S = V(G,S);

//      VGS
   VGS = V_G_S;
   if((VGS < -1.98) && (!VGS_retc))
   begin
     outfile=$fopen("./occ.err","a");
     $strobe("ne       VGS    leaving  OCA ( < -1.980  V )             at %7.4r  %M", $abstime );
     $fwrite(outfile,"ne       VGS    leaving  OCA ( < -1.980  V )             at %7.4r  %M\n", $abstime );
     VGS_retc=1;
     $fclose(outfile);
   end
   if((VGS > 1.98) && (!VGS_retc))
   begin
     outfile=$fopen("./occ.err","a");
     $strobe("ne       VGS    leaving  OCA ( > 1.980  V )              at %7.4r  %M", $abstime );
     $fwrite(outfile,"ne       VGS    leaving  OCA ( > 1.980  V )              at %7.4r  %M\n", $abstime );
     VGS_retc=1;
     $fclose(outfile);
   end
   if((VGS > -1.98) && (VGS < 1.98) && (VGS_retc))
   begin
     outfile=$fopen("./occ.err","a");
     $strobe("ne       VGS    entering OCA ( -1.980  V .. 1.980  V )   at %7.4r  %M", $abstime );
     $fwrite(outfile,"ne       VGS    entering OCA ( -1.980  V .. 1.980  V )   at %7.4r  %M\n", $abstime );
     VGS_retc=0;
     $fclose(outfile);
   end

//      VGD
   VGD = V_G_D;
   if((VGD < -1.98) && (!VGD_retc))
   begin
     outfile=$fopen("./occ.err","a");
     $strobe("ne       VGD    leaving  OCA ( < -1.980  V )             at %7.4r  %M", $abstime );
     $fwrite(outfile,"ne       VGD    leaving  OCA ( < -1.980  V )             at %7.4r  %M\n", $abstime );
     VGD_retc=1;
     $fclose(outfile);
   end
   if((VGD > 1.98) && (!VGD_retc))
   begin
     outfile=$fopen("./occ.err","a");
     $strobe("ne       VGD    leaving  OCA ( > 1.980  V )              at %7.4r  %M", $abstime );
     $fwrite(outfile,"ne       VGD    leaving  OCA ( > 1.980  V )              at %7.4r  %M\n", $abstime );
     VGD_retc=1;
     $fclose(outfile);
   end
   if((VGD > -1.98) && (VGD < 1.98) && (VGD_retc))
   begin
     outfile=$fopen("./occ.err","a");
     $strobe("ne       VGD    entering OCA ( -1.980  V .. 1.980  V )   at %7.4r  %M", $abstime );
     $fwrite(outfile,"ne       VGD    entering OCA ( -1.980  V .. 1.980  V )   at %7.4r  %M\n", $abstime );
     VGD_retc=0;
     $fclose(outfile);
   end

//      VDS
   VDS = V_D_S;
   if((VDS < -1.98) && (!VDS_retc))
   begin
     outfile=$fopen("./occ.err","a");
     $strobe("ne       VDS    leaving  OCA ( < -1.980  V )             at %7.4r  %M", $abstime );
     $fwrite(outfile,"ne       VDS    leaving  OCA ( < -1.980  V )             at %7.4r  %M\n", $abstime );
     VDS_retc=1;
     $fclose(outfile);
   end
   if((VDS > 1.98) && (!VDS_retc))
   begin
     outfile=$fopen("./occ.err","a");
     $strobe("ne       VDS    leaving  OCA ( > 1.980  V )              at %7.4r  %M", $abstime );
     $fwrite(outfile,"ne       VDS    leaving  OCA ( > 1.980  V )              at %7.4r  %M\n", $abstime );
     VDS_retc=1;
     $fclose(outfile);
   end
   if((VDS > -1.98) && (VDS < 1.98) && (VDS_retc))
   begin
     outfile=$fopen("./occ.err","a");
     $strobe("ne       VDS    entering OCA ( -1.980  V .. 1.980  V )   at %7.4r  %M", $abstime );
     $fwrite(outfile,"ne       VDS    entering OCA ( -1.980  V .. 1.980  V )   at %7.4r  %M\n", $abstime );
     VDS_retc=0;
     $fclose(outfile);
   end

//      VDB
   VDB = V_D_B;
   if((VDB < -0.1) && (!VDB_retc))
   begin
     outfile=$fopen("./occ.err","a");
     $strobe("ne       VDB    leaving  OCA ( < -0.100  V )             at %7.4r  %M", $abstime );
     $fwrite(outfile,"ne       VDB    leaving  OCA ( < -0.100  V )             at %7.4r  %M\n", $abstime );
     VDB_retc=1;
     $fclose(outfile);
   end
   if((VDB > 1.98) && (!VDB_retc))
   begin
     outfile=$fopen("./occ.err","a");
     $strobe("ne       VDB    leaving  OCA ( > 1.980  V )              at %7.4r  %M", $abstime );
     $fwrite(outfile,"ne       VDB    leaving  OCA ( > 1.980  V )              at %7.4r  %M\n", $abstime );
     VDB_retc=1;
     $fclose(outfile);
   end
   if((VDB > -0.1) && (VDB < 1.98) && (VDB_retc))
   begin
     outfile=$fopen("./occ.err","a");
     $strobe("ne       VDB    entering OCA ( -0.100  V .. 1.980  V )   at %7.4r  %M", $abstime );
     $fwrite(outfile,"ne       VDB    entering OCA ( -0.100  V .. 1.980  V )   at %7.4r  %M\n", $abstime );
     VDB_retc=0;
     $fclose(outfile);
   end

//      VSB
   VSB = V_S_B;
   if((VSB < -0.1) && (!VSB_retc))
   begin
     outfile=$fopen("./occ.err","a");
     $strobe("ne       VSB    leaving  OCA ( < -0.100  V )             at %7.4r  %M", $abstime );
     $fwrite(outfile,"ne       VSB    leaving  OCA ( < -0.100  V )             at %7.4r  %M\n", $abstime );
     VSB_retc=1;
     $fclose(outfile);
   end
   if((VSB > 1.98) && (!VSB_retc))
   begin
     outfile=$fopen("./occ.err","a");
     $strobe("ne       VSB    leaving  OCA ( > 1.980  V )              at %7.4r  %M", $abstime );
     $fwrite(outfile,"ne       VSB    leaving  OCA ( > 1.980  V )              at %7.4r  %M\n", $abstime );
     VSB_retc=1;
     $fclose(outfile);
   end
   if((VSB > -0.1) && (VSB < 1.98) && (VSB_retc))
   begin
     outfile=$fopen("./occ.err","a");
     $strobe("ne       VSB    entering OCA ( -0.100  V .. 1.980  V )   at %7.4r  %M", $abstime );
     $fwrite(outfile,"ne       VSB    entering OCA ( -0.100  V .. 1.980  V )   at %7.4r  %M\n", $abstime );
     VSB_retc=0;
     $fclose(outfile);
   end

end // analog
endmodule // ne

// Verilog-A OC Watch for device nei Parameters  VGS VGD VDS VDB VSB VBpsub
module nei_ahdl(D,G,S,B);
parameter tstep_occ=100n;
inout D,G,S,B;
electrical D,G,S,B;

integer outfile;
real V_B;
real V_S_B;
real V_D_B;
real V_D_S;
real V_G_D;
real V_G_S;
real VGS;
integer VGS_retc;
real VGD;
integer VGD_retc;
real VDS;
integer VDS_retc;
real VDB;
integer VDB_retc;
real VSB;
integer VSB_retc;
real VBpsub;
integer VBpsub_retc;

analog begin

   $bound_step( tstep_occ );
   @(initial_step) begin
      VGS_retc=0;
      VGD_retc=0;
      VDS_retc=0;
      VDB_retc=0;
      VSB_retc=0;
      VBpsub_retc=0;
   end
   V_B = V(B);
   V_S_B = V(S,B);
   V_D_B = V(D,B);
   V_D_S = V(D,S);
   V_G_D = V(G,D);
   V_G_S = V(G,S);

//      VGS
   VGS = V_G_S;
   if((VGS < -1.98) && (!VGS_retc))
   begin
     outfile=$fopen("./occ.err","a");
     $strobe("nei      VGS    leaving  OCA ( < -1.980  V )             at %7.4r  %M", $abstime );
     $fwrite(outfile,"nei      VGS    leaving  OCA ( < -1.980  V )             at %7.4r  %M\n", $abstime );
     VGS_retc=1;
     $fclose(outfile);
   end
   if((VGS > 1.98) && (!VGS_retc))
   begin
     outfile=$fopen("./occ.err","a");
     $strobe("nei      VGS    leaving  OCA ( > 1.980  V )              at %7.4r  %M", $abstime );
     $fwrite(outfile,"nei      VGS    leaving  OCA ( > 1.980  V )              at %7.4r  %M\n", $abstime );
     VGS_retc=1;
     $fclose(outfile);
   end
   if((VGS > -1.98) && (VGS < 1.98) && (VGS_retc))
   begin
     outfile=$fopen("./occ.err","a");
     $strobe("nei      VGS    entering OCA ( -1.980  V .. 1.980  V )   at %7.4r  %M", $abstime );
     $fwrite(outfile,"nei      VGS    entering OCA ( -1.980  V .. 1.980  V )   at %7.4r  %M\n", $abstime );
     VGS_retc=0;
     $fclose(outfile);
   end

//      VGD
   VGD = V_G_D;
   if((VGD < -1.98) && (!VGD_retc))
   begin
     outfile=$fopen("./occ.err","a");
     $strobe("nei      VGD    leaving  OCA ( < -1.980  V )             at %7.4r  %M", $abstime );
     $fwrite(outfile,"nei      VGD    leaving  OCA ( < -1.980  V )             at %7.4r  %M\n", $abstime );
     VGD_retc=1;
     $fclose(outfile);
   end
   if((VGD > 1.98) && (!VGD_retc))
   begin
     outfile=$fopen("./occ.err","a");
     $strobe("nei      VGD    leaving  OCA ( > 1.980  V )              at %7.4r  %M", $abstime );
     $fwrite(outfile,"nei      VGD    leaving  OCA ( > 1.980  V )              at %7.4r  %M\n", $abstime );
     VGD_retc=1;
     $fclose(outfile);
   end
   if((VGD > -1.98) && (VGD < 1.98) && (VGD_retc))
   begin
     outfile=$fopen("./occ.err","a");
     $strobe("nei      VGD    entering OCA ( -1.980  V .. 1.980  V )   at %7.4r  %M", $abstime );
     $fwrite(outfile,"nei      VGD    entering OCA ( -1.980  V .. 1.980  V )   at %7.4r  %M\n", $abstime );
     VGD_retc=0;
     $fclose(outfile);
   end

//      VDS
   VDS = V_D_S;
   if((VDS < -1.98) && (!VDS_retc))
   begin
     outfile=$fopen("./occ.err","a");
     $strobe("nei      VDS    leaving  OCA ( < -1.980  V )             at %7.4r  %M", $abstime );
     $fwrite(outfile,"nei      VDS    leaving  OCA ( < -1.980  V )             at %7.4r  %M\n", $abstime );
     VDS_retc=1;
     $fclose(outfile);
   end
   if((VDS > 1.98) && (!VDS_retc))
   begin
     outfile=$fopen("./occ.err","a");
     $strobe("nei      VDS    leaving  OCA ( > 1.980  V )              at %7.4r  %M", $abstime );
     $fwrite(outfile,"nei      VDS    leaving  OCA ( > 1.980  V )              at %7.4r  %M\n", $abstime );
     VDS_retc=1;
     $fclose(outfile);
   end
   if((VDS > -1.98) && (VDS < 1.98) && (VDS_retc))
   begin
     outfile=$fopen("./occ.err","a");
     $strobe("nei      VDS    entering OCA ( -1.980  V .. 1.980  V )   at %7.4r  %M", $abstime );
     $fwrite(outfile,"nei      VDS    entering OCA ( -1.980  V .. 1.980  V )   at %7.4r  %M\n", $abstime );
     VDS_retc=0;
     $fclose(outfile);
   end

//      VDB
   VDB = V_D_B;
   if((VDB < -0.1) && (!VDB_retc))
   begin
     outfile=$fopen("./occ.err","a");
     $strobe("nei      VDB    leaving  OCA ( < -0.100  V )             at %7.4r  %M", $abstime );
     $fwrite(outfile,"nei      VDB    leaving  OCA ( < -0.100  V )             at %7.4r  %M\n", $abstime );
     VDB_retc=1;
     $fclose(outfile);
   end
   if((VDB > 1.98) && (!VDB_retc))
   begin
     outfile=$fopen("./occ.err","a");
     $strobe("nei      VDB    leaving  OCA ( > 1.980  V )              at %7.4r  %M", $abstime );
     $fwrite(outfile,"nei      VDB    leaving  OCA ( > 1.980  V )              at %7.4r  %M\n", $abstime );
     VDB_retc=1;
     $fclose(outfile);
   end
   if((VDB > -0.1) && (VDB < 1.98) && (VDB_retc))
   begin
     outfile=$fopen("./occ.err","a");
     $strobe("nei      VDB    entering OCA ( -0.100  V .. 1.980  V )   at %7.4r  %M", $abstime );
     $fwrite(outfile,"nei      VDB    entering OCA ( -0.100  V .. 1.980  V )   at %7.4r  %M\n", $abstime );
     VDB_retc=0;
     $fclose(outfile);
   end

//      VSB
   VSB = V_S_B;
   if((VSB < -0.1) && (!VSB_retc))
   begin
     outfile=$fopen("./occ.err","a");
     $strobe("nei      VSB    leaving  OCA ( < -0.100  V )             at %7.4r  %M", $abstime );
     $fwrite(outfile,"nei      VSB    leaving  OCA ( < -0.100  V )             at %7.4r  %M\n", $abstime );
     VSB_retc=1;
     $fclose(outfile);
   end
   if((VSB > 1.98) && (!VSB_retc))
   begin
     outfile=$fopen("./occ.err","a");
     $strobe("nei      VSB    leaving  OCA ( > 1.980  V )              at %7.4r  %M", $abstime );
     $fwrite(outfile,"nei      VSB    leaving  OCA ( > 1.980  V )              at %7.4r  %M\n", $abstime );
     VSB_retc=1;
     $fclose(outfile);
   end
   if((VSB > -0.1) && (VSB < 1.98) && (VSB_retc))
   begin
     outfile=$fopen("./occ.err","a");
     $strobe("nei      VSB    entering OCA ( -0.100  V .. 1.980  V )   at %7.4r  %M", $abstime );
     $fwrite(outfile,"nei      VSB    entering OCA ( -0.100  V .. 1.980  V )   at %7.4r  %M\n", $abstime );
     VSB_retc=0;
     $fclose(outfile);
   end

//      VBpsub
   VBpsub = V_B;
   if((VBpsub < -1) && (!VBpsub_retc))
   begin
     outfile=$fopen("./occ.err","a");
     $strobe("nei      VBpsub leaving  OCA ( < -1.000  V )             at %7.4r  %M", $abstime );
     $fwrite(outfile,"nei      VBpsub leaving  OCA ( < -1.000  V )             at %7.4r  %M\n", $abstime );
     VBpsub_retc=1;
     $fclose(outfile);
   end
   if((VBpsub > 1) && (!VBpsub_retc))
   begin
     outfile=$fopen("./occ.err","a");
     $strobe("nei      VBpsub leaving  OCA ( > 1.000  V )              at %7.4r  %M", $abstime );
     $fwrite(outfile,"nei      VBpsub leaving  OCA ( > 1.000  V )              at %7.4r  %M\n", $abstime );
     VBpsub_retc=1;
     $fclose(outfile);
   end
   if((VBpsub > -1) && (VBpsub < 1) && (VBpsub_retc))
   begin
     outfile=$fopen("./occ.err","a");
     $strobe("nei      VBpsub entering OCA ( -1.000  V .. 1.000  V )   at %7.4r  %M", $abstime );
     $fwrite(outfile,"nei      VBpsub entering OCA ( -1.000  V .. 1.000  V )   at %7.4r  %M\n", $abstime );
     VBpsub_retc=0;
     $fclose(outfile);
   end

end // analog
endmodule // nei

// Verilog-A OC Watch for device ne3 Parameters  VGS VGD VDS VDB VSB
module ne3_ahdl(D,G,S,B);
parameter tstep_occ=100n;
inout D,G,S,B;
electrical D,G,S,B;

integer outfile;
real V_S_B;
real V_D_B;
real V_D_S;
real V_G_D;
real V_G_S;
real VGS;
integer VGS_retc;
real VGD;
integer VGD_retc;
real VDS;
integer VDS_retc;
real VDB;
integer VDB_retc;
real VSB;
integer VSB_retc;

analog begin

   $bound_step( tstep_occ );
   @(initial_step) begin
      VGS_retc=0;
      VGD_retc=0;
      VDS_retc=0;
      VDB_retc=0;
      VSB_retc=0;
   end
   V_S_B = V(S,B);
   V_D_B = V(D,B);
   V_D_S = V(D,S);
   V_G_D = V(G,D);
   V_G_S = V(G,S);

//      VGS
   VGS = V_G_S;
   if((VGS < -3.6) && (!VGS_retc))
   begin
     outfile=$fopen("./occ.err","a");
     $strobe("ne3      VGS    leaving  OCA ( < -3.600  V )             at %7.4r  %M", $abstime );
     $fwrite(outfile,"ne3      VGS    leaving  OCA ( < -3.600  V )             at %7.4r  %M\n", $abstime );
     VGS_retc=1;
     $fclose(outfile);
   end
   if((VGS > 3.6) && (!VGS_retc))
   begin
     outfile=$fopen("./occ.err","a");
     $strobe("ne3      VGS    leaving  OCA ( > 3.600  V )              at %7.4r  %M", $abstime );
     $fwrite(outfile,"ne3      VGS    leaving  OCA ( > 3.600  V )              at %7.4r  %M\n", $abstime );
     VGS_retc=1;
     $fclose(outfile);
   end
   if((VGS > -3.6) && (VGS < 3.6) && (VGS_retc))
   begin
     outfile=$fopen("./occ.err","a");
     $strobe("ne3      VGS    entering OCA ( -3.600  V .. 3.600  V )   at %7.4r  %M", $abstime );
     $fwrite(outfile,"ne3      VGS    entering OCA ( -3.600  V .. 3.600  V )   at %7.4r  %M\n", $abstime );
     VGS_retc=0;
     $fclose(outfile);
   end

//      VGD
   VGD = V_G_D;
   if((VGD < -3.6) && (!VGD_retc))
   begin
     outfile=$fopen("./occ.err","a");
     $strobe("ne3      VGD    leaving  OCA ( < -3.600  V )             at %7.4r  %M", $abstime );
     $fwrite(outfile,"ne3      VGD    leaving  OCA ( < -3.600  V )             at %7.4r  %M\n", $abstime );
     VGD_retc=1;
     $fclose(outfile);
   end
   if((VGD > 3.6) && (!VGD_retc))
   begin
     outfile=$fopen("./occ.err","a");
     $strobe("ne3      VGD    leaving  OCA ( > 3.600  V )              at %7.4r  %M", $abstime );
     $fwrite(outfile,"ne3      VGD    leaving  OCA ( > 3.600  V )              at %7.4r  %M\n", $abstime );
     VGD_retc=1;
     $fclose(outfile);
   end
   if((VGD > -3.6) && (VGD < 3.6) && (VGD_retc))
   begin
     outfile=$fopen("./occ.err","a");
     $strobe("ne3      VGD    entering OCA ( -3.600  V .. 3.600  V )   at %7.4r  %M", $abstime );
     $fwrite(outfile,"ne3      VGD    entering OCA ( -3.600  V .. 3.600  V )   at %7.4r  %M\n", $abstime );
     VGD_retc=0;
     $fclose(outfile);
   end

//      VDS
   VDS = V_D_S;
   if((VDS < -3.6) && (!VDS_retc))
   begin
     outfile=$fopen("./occ.err","a");
     $strobe("ne3      VDS    leaving  OCA ( < -3.600  V )             at %7.4r  %M", $abstime );
     $fwrite(outfile,"ne3      VDS    leaving  OCA ( < -3.600  V )             at %7.4r  %M\n", $abstime );
     VDS_retc=1;
     $fclose(outfile);
   end
   if((VDS > 3.6) && (!VDS_retc))
   begin
     outfile=$fopen("./occ.err","a");
     $strobe("ne3      VDS    leaving  OCA ( > 3.600  V )              at %7.4r  %M", $abstime );
     $fwrite(outfile,"ne3      VDS    leaving  OCA ( > 3.600  V )              at %7.4r  %M\n", $abstime );
     VDS_retc=1;
     $fclose(outfile);
   end
   if((VDS > -3.6) && (VDS < 3.6) && (VDS_retc))
   begin
     outfile=$fopen("./occ.err","a");
     $strobe("ne3      VDS    entering OCA ( -3.600  V .. 3.600  V )   at %7.4r  %M", $abstime );
     $fwrite(outfile,"ne3      VDS    entering OCA ( -3.600  V .. 3.600  V )   at %7.4r  %M\n", $abstime );
     VDS_retc=0;
     $fclose(outfile);
   end

//      VDB
   VDB = V_D_B;
   if((VDB < -0.1) && (!VDB_retc))
   begin
     outfile=$fopen("./occ.err","a");
     $strobe("ne3      VDB    leaving  OCA ( < -0.100  V )             at %7.4r  %M", $abstime );
     $fwrite(outfile,"ne3      VDB    leaving  OCA ( < -0.100  V )             at %7.4r  %M\n", $abstime );
     VDB_retc=1;
     $fclose(outfile);
   end
   if((VDB > 3.6) && (!VDB_retc))
   begin
     outfile=$fopen("./occ.err","a");
     $strobe("ne3      VDB    leaving  OCA ( > 3.600  V )              at %7.4r  %M", $abstime );
     $fwrite(outfile,"ne3      VDB    leaving  OCA ( > 3.600  V )              at %7.4r  %M\n", $abstime );
     VDB_retc=1;
     $fclose(outfile);
   end
   if((VDB > -0.1) && (VDB < 3.6) && (VDB_retc))
   begin
     outfile=$fopen("./occ.err","a");
     $strobe("ne3      VDB    entering OCA ( -0.100  V .. 3.600  V )   at %7.4r  %M", $abstime );
     $fwrite(outfile,"ne3      VDB    entering OCA ( -0.100  V .. 3.600  V )   at %7.4r  %M\n", $abstime );
     VDB_retc=0;
     $fclose(outfile);
   end

//      VSB
   VSB = V_S_B;
   if((VSB < -0.1) && (!VSB_retc))
   begin
     outfile=$fopen("./occ.err","a");
     $strobe("ne3      VSB    leaving  OCA ( < -0.100  V )             at %7.4r  %M", $abstime );
     $fwrite(outfile,"ne3      VSB    leaving  OCA ( < -0.100  V )             at %7.4r  %M\n", $abstime );
     VSB_retc=1;
     $fclose(outfile);
   end
   if((VSB > 3.6) && (!VSB_retc))
   begin
     outfile=$fopen("./occ.err","a");
     $strobe("ne3      VSB    leaving  OCA ( > 3.600  V )              at %7.4r  %M", $abstime );
     $fwrite(outfile,"ne3      VSB    leaving  OCA ( > 3.600  V )              at %7.4r  %M\n", $abstime );
     VSB_retc=1;
     $fclose(outfile);
   end
   if((VSB > -0.1) && (VSB < 3.6) && (VSB_retc))
   begin
     outfile=$fopen("./occ.err","a");
     $strobe("ne3      VSB    entering OCA ( -0.100  V .. 3.600  V )   at %7.4r  %M", $abstime );
     $fwrite(outfile,"ne3      VSB    entering OCA ( -0.100  V .. 3.600  V )   at %7.4r  %M\n", $abstime );
     VSB_retc=0;
     $fclose(outfile);
   end

end // analog
endmodule // ne3

// Verilog-A OC Watch for device nn3 Parameters  VGS VGD VDS VDB VSB
module nn3_ahdl(D,G,S,B);
parameter tstep_occ=100n;
inout D,G,S,B;
electrical D,G,S,B;

integer outfile;
real V_S_B;
real V_D_B;
real V_D_S;
real V_G_D;
real V_G_S;
real VGS;
integer VGS_retc;
real VGD;
integer VGD_retc;
real VDS;
integer VDS_retc;
real VDB;
integer VDB_retc;
real VSB;
integer VSB_retc;

analog begin

   $bound_step( tstep_occ );
   @(initial_step) begin
      VGS_retc=0;
      VGD_retc=0;
      VDS_retc=0;
      VDB_retc=0;
      VSB_retc=0;
   end
   V_S_B = V(S,B);
   V_D_B = V(D,B);
   V_D_S = V(D,S);
   V_G_D = V(G,D);
   V_G_S = V(G,S);

//      VGS
   VGS = V_G_S;
   if((VGS < -3.6) && (!VGS_retc))
   begin
     outfile=$fopen("./occ.err","a");
     $strobe("nn3      VGS    leaving  OCA ( < -3.600  V )             at %7.4r  %M", $abstime );
     $fwrite(outfile,"nn3      VGS    leaving  OCA ( < -3.600  V )             at %7.4r  %M\n", $abstime );
     VGS_retc=1;
     $fclose(outfile);
   end
   if((VGS > 3.6) && (!VGS_retc))
   begin
     outfile=$fopen("./occ.err","a");
     $strobe("nn3      VGS    leaving  OCA ( > 3.600  V )              at %7.4r  %M", $abstime );
     $fwrite(outfile,"nn3      VGS    leaving  OCA ( > 3.600  V )              at %7.4r  %M\n", $abstime );
     VGS_retc=1;
     $fclose(outfile);
   end
   if((VGS > -3.6) && (VGS < 3.6) && (VGS_retc))
   begin
     outfile=$fopen("./occ.err","a");
     $strobe("nn3      VGS    entering OCA ( -3.600  V .. 3.600  V )   at %7.4r  %M", $abstime );
     $fwrite(outfile,"nn3      VGS    entering OCA ( -3.600  V .. 3.600  V )   at %7.4r  %M\n", $abstime );
     VGS_retc=0;
     $fclose(outfile);
   end

//      VGD
   VGD = V_G_D;
   if((VGD < -3.6) && (!VGD_retc))
   begin
     outfile=$fopen("./occ.err","a");
     $strobe("nn3      VGD    leaving  OCA ( < -3.600  V )             at %7.4r  %M", $abstime );
     $fwrite(outfile,"nn3      VGD    leaving  OCA ( < -3.600  V )             at %7.4r  %M\n", $abstime );
     VGD_retc=1;
     $fclose(outfile);
   end
   if((VGD > 3.6) && (!VGD_retc))
   begin
     outfile=$fopen("./occ.err","a");
     $strobe("nn3      VGD    leaving  OCA ( > 3.600  V )              at %7.4r  %M", $abstime );
     $fwrite(outfile,"nn3      VGD    leaving  OCA ( > 3.600  V )              at %7.4r  %M\n", $abstime );
     VGD_retc=1;
     $fclose(outfile);
   end
   if((VGD > -3.6) && (VGD < 3.6) && (VGD_retc))
   begin
     outfile=$fopen("./occ.err","a");
     $strobe("nn3      VGD    entering OCA ( -3.600  V .. 3.600  V )   at %7.4r  %M", $abstime );
     $fwrite(outfile,"nn3      VGD    entering OCA ( -3.600  V .. 3.600  V )   at %7.4r  %M\n", $abstime );
     VGD_retc=0;
     $fclose(outfile);
   end

//      VDS
   VDS = V_D_S;
   if((VDS < -3.6) && (!VDS_retc))
   begin
     outfile=$fopen("./occ.err","a");
     $strobe("nn3      VDS    leaving  OCA ( < -3.600  V )             at %7.4r  %M", $abstime );
     $fwrite(outfile,"nn3      VDS    leaving  OCA ( < -3.600  V )             at %7.4r  %M\n", $abstime );
     VDS_retc=1;
     $fclose(outfile);
   end
   if((VDS > 3.6) && (!VDS_retc))
   begin
     outfile=$fopen("./occ.err","a");
     $strobe("nn3      VDS    leaving  OCA ( > 3.600  V )              at %7.4r  %M", $abstime );
     $fwrite(outfile,"nn3      VDS    leaving  OCA ( > 3.600  V )              at %7.4r  %M\n", $abstime );
     VDS_retc=1;
     $fclose(outfile);
   end
   if((VDS > -3.6) && (VDS < 3.6) && (VDS_retc))
   begin
     outfile=$fopen("./occ.err","a");
     $strobe("nn3      VDS    entering OCA ( -3.600  V .. 3.600  V )   at %7.4r  %M", $abstime );
     $fwrite(outfile,"nn3      VDS    entering OCA ( -3.600  V .. 3.600  V )   at %7.4r  %M\n", $abstime );
     VDS_retc=0;
     $fclose(outfile);
   end

//      VDB
   VDB = V_D_B;
   if((VDB < -0.1) && (!VDB_retc))
   begin
     outfile=$fopen("./occ.err","a");
     $strobe("nn3      VDB    leaving  OCA ( < -0.100  V )             at %7.4r  %M", $abstime );
     $fwrite(outfile,"nn3      VDB    leaving  OCA ( < -0.100  V )             at %7.4r  %M\n", $abstime );
     VDB_retc=1;
     $fclose(outfile);
   end
   if((VDB > 3.6) && (!VDB_retc))
   begin
     outfile=$fopen("./occ.err","a");
     $strobe("nn3      VDB    leaving  OCA ( > 3.600  V )              at %7.4r  %M", $abstime );
     $fwrite(outfile,"nn3      VDB    leaving  OCA ( > 3.600  V )              at %7.4r  %M\n", $abstime );
     VDB_retc=1;
     $fclose(outfile);
   end
   if((VDB > -0.1) && (VDB < 3.6) && (VDB_retc))
   begin
     outfile=$fopen("./occ.err","a");
     $strobe("nn3      VDB    entering OCA ( -0.100  V .. 3.600  V )   at %7.4r  %M", $abstime );
     $fwrite(outfile,"nn3      VDB    entering OCA ( -0.100  V .. 3.600  V )   at %7.4r  %M\n", $abstime );
     VDB_retc=0;
     $fclose(outfile);
   end

//      VSB
   VSB = V_S_B;
   if((VSB < -0.1) && (!VSB_retc))
   begin
     outfile=$fopen("./occ.err","a");
     $strobe("nn3      VSB    leaving  OCA ( < -0.100  V )             at %7.4r  %M", $abstime );
     $fwrite(outfile,"nn3      VSB    leaving  OCA ( < -0.100  V )             at %7.4r  %M\n", $abstime );
     VSB_retc=1;
     $fclose(outfile);
   end
   if((VSB > 3.6) && (!VSB_retc))
   begin
     outfile=$fopen("./occ.err","a");
     $strobe("nn3      VSB    leaving  OCA ( > 3.600  V )              at %7.4r  %M", $abstime );
     $fwrite(outfile,"nn3      VSB    leaving  OCA ( > 3.600  V )              at %7.4r  %M\n", $abstime );
     VSB_retc=1;
     $fclose(outfile);
   end
   if((VSB > -0.1) && (VSB < 3.6) && (VSB_retc))
   begin
     outfile=$fopen("./occ.err","a");
     $strobe("nn3      VSB    entering OCA ( -0.100  V .. 3.600  V )   at %7.4r  %M", $abstime );
     $fwrite(outfile,"nn3      VSB    entering OCA ( -0.100  V .. 3.600  V )   at %7.4r  %M\n", $abstime );
     VSB_retc=0;
     $fclose(outfile);
   end

end // analog
endmodule // nn3

// Verilog-A OC Watch for device nd3 Parameters  VGS VGD VDS VDB VSB
module nd3_ahdl(D,G,S,B);
parameter tstep_occ=100n;
inout D,G,S,B;
electrical D,G,S,B;

integer outfile;
real V_S_B;
real V_D_B;
real V_D_S;
real V_G_D;
real V_G_S;
real VGS;
integer VGS_retc;
real VGD;
integer VGD_retc;
real VDS;
integer VDS_retc;
real VDB;
integer VDB_retc;
real VSB;
integer VSB_retc;

analog begin

   $bound_step( tstep_occ );
   @(initial_step) begin
      VGS_retc=0;
      VGD_retc=0;
      VDS_retc=0;
      VDB_retc=0;
      VSB_retc=0;
   end
   V_S_B = V(S,B);
   V_D_B = V(D,B);
   V_D_S = V(D,S);
   V_G_D = V(G,D);
   V_G_S = V(G,S);

//      VGS
   VGS = V_G_S;
   if((VGS < -3.6) && (!VGS_retc))
   begin
     outfile=$fopen("./occ.err","a");
     $strobe("nd3      VGS    leaving  OCA ( < -3.600  V )             at %7.4r  %M", $abstime );
     $fwrite(outfile,"nd3      VGS    leaving  OCA ( < -3.600  V )             at %7.4r  %M\n", $abstime );
     VGS_retc=1;
     $fclose(outfile);
   end
   if((VGS > 3.6) && (!VGS_retc))
   begin
     outfile=$fopen("./occ.err","a");
     $strobe("nd3      VGS    leaving  OCA ( > 3.600  V )              at %7.4r  %M", $abstime );
     $fwrite(outfile,"nd3      VGS    leaving  OCA ( > 3.600  V )              at %7.4r  %M\n", $abstime );
     VGS_retc=1;
     $fclose(outfile);
   end
   if((VGS > -3.6) && (VGS < 3.6) && (VGS_retc))
   begin
     outfile=$fopen("./occ.err","a");
     $strobe("nd3      VGS    entering OCA ( -3.600  V .. 3.600  V )   at %7.4r  %M", $abstime );
     $fwrite(outfile,"nd3      VGS    entering OCA ( -3.600  V .. 3.600  V )   at %7.4r  %M\n", $abstime );
     VGS_retc=0;
     $fclose(outfile);
   end

//      VGD
   VGD = V_G_D;
   if((VGD < -3.6) && (!VGD_retc))
   begin
     outfile=$fopen("./occ.err","a");
     $strobe("nd3      VGD    leaving  OCA ( < -3.600  V )             at %7.4r  %M", $abstime );
     $fwrite(outfile,"nd3      VGD    leaving  OCA ( < -3.600  V )             at %7.4r  %M\n", $abstime );
     VGD_retc=1;
     $fclose(outfile);
   end
   if((VGD > 3.6) && (!VGD_retc))
   begin
     outfile=$fopen("./occ.err","a");
     $strobe("nd3      VGD    leaving  OCA ( > 3.600  V )              at %7.4r  %M", $abstime );
     $fwrite(outfile,"nd3      VGD    leaving  OCA ( > 3.600  V )              at %7.4r  %M\n", $abstime );
     VGD_retc=1;
     $fclose(outfile);
   end
   if((VGD > -3.6) && (VGD < 3.6) && (VGD_retc))
   begin
     outfile=$fopen("./occ.err","a");
     $strobe("nd3      VGD    entering OCA ( -3.600  V .. 3.600  V )   at %7.4r  %M", $abstime );
     $fwrite(outfile,"nd3      VGD    entering OCA ( -3.600  V .. 3.600  V )   at %7.4r  %M\n", $abstime );
     VGD_retc=0;
     $fclose(outfile);
   end

//      VDS
   VDS = V_D_S;
   if((VDS < -3.6) && (!VDS_retc))
   begin
     outfile=$fopen("./occ.err","a");
     $strobe("nd3      VDS    leaving  OCA ( < -3.600  V )             at %7.4r  %M", $abstime );
     $fwrite(outfile,"nd3      VDS    leaving  OCA ( < -3.600  V )             at %7.4r  %M\n", $abstime );
     VDS_retc=1;
     $fclose(outfile);
   end
   if((VDS > 3.6) && (!VDS_retc))
   begin
     outfile=$fopen("./occ.err","a");
     $strobe("nd3      VDS    leaving  OCA ( > 3.600  V )              at %7.4r  %M", $abstime );
     $fwrite(outfile,"nd3      VDS    leaving  OCA ( > 3.600  V )              at %7.4r  %M\n", $abstime );
     VDS_retc=1;
     $fclose(outfile);
   end
   if((VDS > -3.6) && (VDS < 3.6) && (VDS_retc))
   begin
     outfile=$fopen("./occ.err","a");
     $strobe("nd3      VDS    entering OCA ( -3.600  V .. 3.600  V )   at %7.4r  %M", $abstime );
     $fwrite(outfile,"nd3      VDS    entering OCA ( -3.600  V .. 3.600  V )   at %7.4r  %M\n", $abstime );
     VDS_retc=0;
     $fclose(outfile);
   end

//      VDB
   VDB = V_D_B;
   if((VDB < -0.1) && (!VDB_retc))
   begin
     outfile=$fopen("./occ.err","a");
     $strobe("nd3      VDB    leaving  OCA ( < -0.100  V )             at %7.4r  %M", $abstime );
     $fwrite(outfile,"nd3      VDB    leaving  OCA ( < -0.100  V )             at %7.4r  %M\n", $abstime );
     VDB_retc=1;
     $fclose(outfile);
   end
   if((VDB > 3.6) && (!VDB_retc))
   begin
     outfile=$fopen("./occ.err","a");
     $strobe("nd3      VDB    leaving  OCA ( > 3.600  V )              at %7.4r  %M", $abstime );
     $fwrite(outfile,"nd3      VDB    leaving  OCA ( > 3.600  V )              at %7.4r  %M\n", $abstime );
     VDB_retc=1;
     $fclose(outfile);
   end
   if((VDB > -0.1) && (VDB < 3.6) && (VDB_retc))
   begin
     outfile=$fopen("./occ.err","a");
     $strobe("nd3      VDB    entering OCA ( -0.100  V .. 3.600  V )   at %7.4r  %M", $abstime );
     $fwrite(outfile,"nd3      VDB    entering OCA ( -0.100  V .. 3.600  V )   at %7.4r  %M\n", $abstime );
     VDB_retc=0;
     $fclose(outfile);
   end

//      VSB
   VSB = V_S_B;
   if((VSB < -0.1) && (!VSB_retc))
   begin
     outfile=$fopen("./occ.err","a");
     $strobe("nd3      VSB    leaving  OCA ( < -0.100  V )             at %7.4r  %M", $abstime );
     $fwrite(outfile,"nd3      VSB    leaving  OCA ( < -0.100  V )             at %7.4r  %M\n", $abstime );
     VSB_retc=1;
     $fclose(outfile);
   end
   if((VSB > 3.6) && (!VSB_retc))
   begin
     outfile=$fopen("./occ.err","a");
     $strobe("nd3      VSB    leaving  OCA ( > 3.600  V )              at %7.4r  %M", $abstime );
     $fwrite(outfile,"nd3      VSB    leaving  OCA ( > 3.600  V )              at %7.4r  %M\n", $abstime );
     VSB_retc=1;
     $fclose(outfile);
   end
   if((VSB > -0.1) && (VSB < 3.6) && (VSB_retc))
   begin
     outfile=$fopen("./occ.err","a");
     $strobe("nd3      VSB    entering OCA ( -0.100  V .. 3.600  V )   at %7.4r  %M", $abstime );
     $fwrite(outfile,"nd3      VSB    entering OCA ( -0.100  V .. 3.600  V )   at %7.4r  %M\n", $abstime );
     VSB_retc=0;
     $fclose(outfile);
   end

end // analog
endmodule // nd3

// Verilog-A OC Watch for device ne3i Parameters  VGS VGD VDS VDB VSB VB
module ne3i_ahdl(D,G,S,B);
parameter tstep_occ=100n;
inout D,G,S,B;
electrical D,G,S,B;

integer outfile;
real V_B;
real V_S_B;
real V_D_B;
real V_D_S;
real V_G_D;
real V_G_S;
real VGS;
integer VGS_retc;
real VGD;
integer VGD_retc;
real VDS;
integer VDS_retc;
real VDB;
integer VDB_retc;
real VSB;
integer VSB_retc;
real VB;
integer VB_retc;

analog begin

   $bound_step( tstep_occ );
   @(initial_step) begin
      VGS_retc=0;
      VGD_retc=0;
      VDS_retc=0;
      VDB_retc=0;
      VSB_retc=0;
      VB_retc=0;
   end
   V_B = V(B);
   V_S_B = V(S,B);
   V_D_B = V(D,B);
   V_D_S = V(D,S);
   V_G_D = V(G,D);
   V_G_S = V(G,S);

//      VGS
   VGS = V_G_S;
   if((VGS < -3.6) && (!VGS_retc))
   begin
     outfile=$fopen("./occ.err","a");
     $strobe("ne3i     VGS    leaving  OCA ( < -3.600  V )             at %7.4r  %M", $abstime );
     $fwrite(outfile,"ne3i     VGS    leaving  OCA ( < -3.600  V )             at %7.4r  %M\n", $abstime );
     VGS_retc=1;
     $fclose(outfile);
   end
   if((VGS > 3.6) && (!VGS_retc))
   begin
     outfile=$fopen("./occ.err","a");
     $strobe("ne3i     VGS    leaving  OCA ( > 3.600  V )              at %7.4r  %M", $abstime );
     $fwrite(outfile,"ne3i     VGS    leaving  OCA ( > 3.600  V )              at %7.4r  %M\n", $abstime );
     VGS_retc=1;
     $fclose(outfile);
   end
   if((VGS > -3.6) && (VGS < 3.6) && (VGS_retc))
   begin
     outfile=$fopen("./occ.err","a");
     $strobe("ne3i     VGS    entering OCA ( -3.600  V .. 3.600  V )   at %7.4r  %M", $abstime );
     $fwrite(outfile,"ne3i     VGS    entering OCA ( -3.600  V .. 3.600  V )   at %7.4r  %M\n", $abstime );
     VGS_retc=0;
     $fclose(outfile);
   end

//      VGD
   VGD = V_G_D;
   if((VGD < -3.6) && (!VGD_retc))
   begin
     outfile=$fopen("./occ.err","a");
     $strobe("ne3i     VGD    leaving  OCA ( < -3.600  V )             at %7.4r  %M", $abstime );
     $fwrite(outfile,"ne3i     VGD    leaving  OCA ( < -3.600  V )             at %7.4r  %M\n", $abstime );
     VGD_retc=1;
     $fclose(outfile);
   end
   if((VGD > 3.6) && (!VGD_retc))
   begin
     outfile=$fopen("./occ.err","a");
     $strobe("ne3i     VGD    leaving  OCA ( > 3.600  V )              at %7.4r  %M", $abstime );
     $fwrite(outfile,"ne3i     VGD    leaving  OCA ( > 3.600  V )              at %7.4r  %M\n", $abstime );
     VGD_retc=1;
     $fclose(outfile);
   end
   if((VGD > -3.6) && (VGD < 3.6) && (VGD_retc))
   begin
     outfile=$fopen("./occ.err","a");
     $strobe("ne3i     VGD    entering OCA ( -3.600  V .. 3.600  V )   at %7.4r  %M", $abstime );
     $fwrite(outfile,"ne3i     VGD    entering OCA ( -3.600  V .. 3.600  V )   at %7.4r  %M\n", $abstime );
     VGD_retc=0;
     $fclose(outfile);
   end

//      VDS
   VDS = V_D_S;
   if((VDS < -3.6) && (!VDS_retc))
   begin
     outfile=$fopen("./occ.err","a");
     $strobe("ne3i     VDS    leaving  OCA ( < -3.600  V )             at %7.4r  %M", $abstime );
     $fwrite(outfile,"ne3i     VDS    leaving  OCA ( < -3.600  V )             at %7.4r  %M\n", $abstime );
     VDS_retc=1;
     $fclose(outfile);
   end
   if((VDS > 3.6) && (!VDS_retc))
   begin
     outfile=$fopen("./occ.err","a");
     $strobe("ne3i     VDS    leaving  OCA ( > 3.600  V )              at %7.4r  %M", $abstime );
     $fwrite(outfile,"ne3i     VDS    leaving  OCA ( > 3.600  V )              at %7.4r  %M\n", $abstime );
     VDS_retc=1;
     $fclose(outfile);
   end
   if((VDS > -3.6) && (VDS < 3.6) && (VDS_retc))
   begin
     outfile=$fopen("./occ.err","a");
     $strobe("ne3i     VDS    entering OCA ( -3.600  V .. 3.600  V )   at %7.4r  %M", $abstime );
     $fwrite(outfile,"ne3i     VDS    entering OCA ( -3.600  V .. 3.600  V )   at %7.4r  %M\n", $abstime );
     VDS_retc=0;
     $fclose(outfile);
   end

//      VDB
   VDB = V_D_B;
   if((VDB < -0.1) && (!VDB_retc))
   begin
     outfile=$fopen("./occ.err","a");
     $strobe("ne3i     VDB    leaving  OCA ( < -0.100  V )             at %7.4r  %M", $abstime );
     $fwrite(outfile,"ne3i     VDB    leaving  OCA ( < -0.100  V )             at %7.4r  %M\n", $abstime );
     VDB_retc=1;
     $fclose(outfile);
   end
   if((VDB > 3.6) && (!VDB_retc))
   begin
     outfile=$fopen("./occ.err","a");
     $strobe("ne3i     VDB    leaving  OCA ( > 3.600  V )              at %7.4r  %M", $abstime );
     $fwrite(outfile,"ne3i     VDB    leaving  OCA ( > 3.600  V )              at %7.4r  %M\n", $abstime );
     VDB_retc=1;
     $fclose(outfile);
   end
   if((VDB > -0.1) && (VDB < 3.6) && (VDB_retc))
   begin
     outfile=$fopen("./occ.err","a");
     $strobe("ne3i     VDB    entering OCA ( -0.100  V .. 3.600  V )   at %7.4r  %M", $abstime );
     $fwrite(outfile,"ne3i     VDB    entering OCA ( -0.100  V .. 3.600  V )   at %7.4r  %M\n", $abstime );
     VDB_retc=0;
     $fclose(outfile);
   end

//      VSB
   VSB = V_S_B;
   if((VSB < -0.1) && (!VSB_retc))
   begin
     outfile=$fopen("./occ.err","a");
     $strobe("ne3i     VSB    leaving  OCA ( < -0.100  V )             at %7.4r  %M", $abstime );
     $fwrite(outfile,"ne3i     VSB    leaving  OCA ( < -0.100  V )             at %7.4r  %M\n", $abstime );
     VSB_retc=1;
     $fclose(outfile);
   end
   if((VSB > 3.6) && (!VSB_retc))
   begin
     outfile=$fopen("./occ.err","a");
     $strobe("ne3i     VSB    leaving  OCA ( > 3.600  V )              at %7.4r  %M", $abstime );
     $fwrite(outfile,"ne3i     VSB    leaving  OCA ( > 3.600  V )              at %7.4r  %M\n", $abstime );
     VSB_retc=1;
     $fclose(outfile);
   end
   if((VSB > -0.1) && (VSB < 3.6) && (VSB_retc))
   begin
     outfile=$fopen("./occ.err","a");
     $strobe("ne3i     VSB    entering OCA ( -0.100  V .. 3.600  V )   at %7.4r  %M", $abstime );
     $fwrite(outfile,"ne3i     VSB    entering OCA ( -0.100  V .. 3.600  V )   at %7.4r  %M\n", $abstime );
     VSB_retc=0;
     $fclose(outfile);
   end

//      VB
   VB = V_B;
   if((VB < -1) && (!VB_retc))
   begin
     outfile=$fopen("./occ.err","a");
     $strobe("ne3i     VB     leaving  OCA ( < -1.000  V )             at %7.4r  %M", $abstime );
     $fwrite(outfile,"ne3i     VB     leaving  OCA ( < -1.000  V )             at %7.4r  %M\n", $abstime );
     VB_retc=1;
     $fclose(outfile);
   end
   if((VB > 1) && (!VB_retc))
   begin
     outfile=$fopen("./occ.err","a");
     $strobe("ne3i     VB     leaving  OCA ( > 1.000  V )              at %7.4r  %M", $abstime );
     $fwrite(outfile,"ne3i     VB     leaving  OCA ( > 1.000  V )              at %7.4r  %M\n", $abstime );
     VB_retc=1;
     $fclose(outfile);
   end
   if((VB > -1) && (VB < 1) && (VB_retc))
   begin
     outfile=$fopen("./occ.err","a");
     $strobe("ne3i     VB     entering OCA ( -1.000  V .. 1.000  V )   at %7.4r  %M", $abstime );
     $fwrite(outfile,"ne3i     VB     entering OCA ( -1.000  V .. 1.000  V )   at %7.4r  %M\n", $abstime );
     VB_retc=0;
     $fclose(outfile);
   end

end // analog
endmodule // ne3i

// Verilog-A OC Watch for device nd3i Parameters  VGS VGD VDS VDB VSB VB
module nd3i_ahdl(D,G,S,B);
parameter tstep_occ=100n;
inout D,G,S,B;
electrical D,G,S,B;

integer outfile;
real V_B;
real V_S_B;
real V_D_B;
real V_D_S;
real V_G_D;
real V_G_S;
real VGS;
integer VGS_retc;
real VGD;
integer VGD_retc;
real VDS;
integer VDS_retc;
real VDB;
integer VDB_retc;
real VSB;
integer VSB_retc;
real VB;
integer VB_retc;

analog begin

   $bound_step( tstep_occ );
   @(initial_step) begin
      VGS_retc=0;
      VGD_retc=0;
      VDS_retc=0;
      VDB_retc=0;
      VSB_retc=0;
      VB_retc=0;
   end
   V_B = V(B);
   V_S_B = V(S,B);
   V_D_B = V(D,B);
   V_D_S = V(D,S);
   V_G_D = V(G,D);
   V_G_S = V(G,S);

//      VGS
   VGS = V_G_S;
   if((VGS < -3.6) && (!VGS_retc))
   begin
     outfile=$fopen("./occ.err","a");
     $strobe("nd3i     VGS    leaving  OCA ( < -3.600  V )             at %7.4r  %M", $abstime );
     $fwrite(outfile,"nd3i     VGS    leaving  OCA ( < -3.600  V )             at %7.4r  %M\n", $abstime );
     VGS_retc=1;
     $fclose(outfile);
   end
   if((VGS > 3.6) && (!VGS_retc))
   begin
     outfile=$fopen("./occ.err","a");
     $strobe("nd3i     VGS    leaving  OCA ( > 3.600  V )              at %7.4r  %M", $abstime );
     $fwrite(outfile,"nd3i     VGS    leaving  OCA ( > 3.600  V )              at %7.4r  %M\n", $abstime );
     VGS_retc=1;
     $fclose(outfile);
   end
   if((VGS > -3.6) && (VGS < 3.6) && (VGS_retc))
   begin
     outfile=$fopen("./occ.err","a");
     $strobe("nd3i     VGS    entering OCA ( -3.600  V .. 3.600  V )   at %7.4r  %M", $abstime );
     $fwrite(outfile,"nd3i     VGS    entering OCA ( -3.600  V .. 3.600  V )   at %7.4r  %M\n", $abstime );
     VGS_retc=0;
     $fclose(outfile);
   end

//      VGD
   VGD = V_G_D;
   if((VGD < -3.6) && (!VGD_retc))
   begin
     outfile=$fopen("./occ.err","a");
     $strobe("nd3i     VGD    leaving  OCA ( < -3.600  V )             at %7.4r  %M", $abstime );
     $fwrite(outfile,"nd3i     VGD    leaving  OCA ( < -3.600  V )             at %7.4r  %M\n", $abstime );
     VGD_retc=1;
     $fclose(outfile);
   end
   if((VGD > 3.6) && (!VGD_retc))
   begin
     outfile=$fopen("./occ.err","a");
     $strobe("nd3i     VGD    leaving  OCA ( > 3.600  V )              at %7.4r  %M", $abstime );
     $fwrite(outfile,"nd3i     VGD    leaving  OCA ( > 3.600  V )              at %7.4r  %M\n", $abstime );
     VGD_retc=1;
     $fclose(outfile);
   end
   if((VGD > -3.6) && (VGD < 3.6) && (VGD_retc))
   begin
     outfile=$fopen("./occ.err","a");
     $strobe("nd3i     VGD    entering OCA ( -3.600  V .. 3.600  V )   at %7.4r  %M", $abstime );
     $fwrite(outfile,"nd3i     VGD    entering OCA ( -3.600  V .. 3.600  V )   at %7.4r  %M\n", $abstime );
     VGD_retc=0;
     $fclose(outfile);
   end

//      VDS
   VDS = V_D_S;
   if((VDS < -3.6) && (!VDS_retc))
   begin
     outfile=$fopen("./occ.err","a");
     $strobe("nd3i     VDS    leaving  OCA ( < -3.600  V )             at %7.4r  %M", $abstime );
     $fwrite(outfile,"nd3i     VDS    leaving  OCA ( < -3.600  V )             at %7.4r  %M\n", $abstime );
     VDS_retc=1;
     $fclose(outfile);
   end
   if((VDS > 3.6) && (!VDS_retc))
   begin
     outfile=$fopen("./occ.err","a");
     $strobe("nd3i     VDS    leaving  OCA ( > 3.600  V )              at %7.4r  %M", $abstime );
     $fwrite(outfile,"nd3i     VDS    leaving  OCA ( > 3.600  V )              at %7.4r  %M\n", $abstime );
     VDS_retc=1;
     $fclose(outfile);
   end
   if((VDS > -3.6) && (VDS < 3.6) && (VDS_retc))
   begin
     outfile=$fopen("./occ.err","a");
     $strobe("nd3i     VDS    entering OCA ( -3.600  V .. 3.600  V )   at %7.4r  %M", $abstime );
     $fwrite(outfile,"nd3i     VDS    entering OCA ( -3.600  V .. 3.600  V )   at %7.4r  %M\n", $abstime );
     VDS_retc=0;
     $fclose(outfile);
   end

//      VDB
   VDB = V_D_B;
   if((VDB < -0.1) && (!VDB_retc))
   begin
     outfile=$fopen("./occ.err","a");
     $strobe("nd3i     VDB    leaving  OCA ( < -0.100  V )             at %7.4r  %M", $abstime );
     $fwrite(outfile,"nd3i     VDB    leaving  OCA ( < -0.100  V )             at %7.4r  %M\n", $abstime );
     VDB_retc=1;
     $fclose(outfile);
   end
   if((VDB > 3.6) && (!VDB_retc))
   begin
     outfile=$fopen("./occ.err","a");
     $strobe("nd3i     VDB    leaving  OCA ( > 3.600  V )              at %7.4r  %M", $abstime );
     $fwrite(outfile,"nd3i     VDB    leaving  OCA ( > 3.600  V )              at %7.4r  %M\n", $abstime );
     VDB_retc=1;
     $fclose(outfile);
   end
   if((VDB > -0.1) && (VDB < 3.6) && (VDB_retc))
   begin
     outfile=$fopen("./occ.err","a");
     $strobe("nd3i     VDB    entering OCA ( -0.100  V .. 3.600  V )   at %7.4r  %M", $abstime );
     $fwrite(outfile,"nd3i     VDB    entering OCA ( -0.100  V .. 3.600  V )   at %7.4r  %M\n", $abstime );
     VDB_retc=0;
     $fclose(outfile);
   end

//      VSB
   VSB = V_S_B;
   if((VSB < -0.1) && (!VSB_retc))
   begin
     outfile=$fopen("./occ.err","a");
     $strobe("nd3i     VSB    leaving  OCA ( < -0.100  V )             at %7.4r  %M", $abstime );
     $fwrite(outfile,"nd3i     VSB    leaving  OCA ( < -0.100  V )             at %7.4r  %M\n", $abstime );
     VSB_retc=1;
     $fclose(outfile);
   end
   if((VSB > 3.6) && (!VSB_retc))
   begin
     outfile=$fopen("./occ.err","a");
     $strobe("nd3i     VSB    leaving  OCA ( > 3.600  V )              at %7.4r  %M", $abstime );
     $fwrite(outfile,"nd3i     VSB    leaving  OCA ( > 3.600  V )              at %7.4r  %M\n", $abstime );
     VSB_retc=1;
     $fclose(outfile);
   end
   if((VSB > -0.1) && (VSB < 3.6) && (VSB_retc))
   begin
     outfile=$fopen("./occ.err","a");
     $strobe("nd3i     VSB    entering OCA ( -0.100  V .. 3.600  V )   at %7.4r  %M", $abstime );
     $fwrite(outfile,"nd3i     VSB    entering OCA ( -0.100  V .. 3.600  V )   at %7.4r  %M\n", $abstime );
     VSB_retc=0;
     $fclose(outfile);
   end

//      VB
   VB = V_B;
   if((VB < -1) && (!VB_retc))
   begin
     outfile=$fopen("./occ.err","a");
     $strobe("nd3i     VB     leaving  OCA ( < -1.000  V )             at %7.4r  %M", $abstime );
     $fwrite(outfile,"nd3i     VB     leaving  OCA ( < -1.000  V )             at %7.4r  %M\n", $abstime );
     VB_retc=1;
     $fclose(outfile);
   end
   if((VB > 1) && (!VB_retc))
   begin
     outfile=$fopen("./occ.err","a");
     $strobe("nd3i     VB     leaving  OCA ( > 1.000  V )              at %7.4r  %M", $abstime );
     $fwrite(outfile,"nd3i     VB     leaving  OCA ( > 1.000  V )              at %7.4r  %M\n", $abstime );
     VB_retc=1;
     $fclose(outfile);
   end
   if((VB > -1) && (VB < 1) && (VB_retc))
   begin
     outfile=$fopen("./occ.err","a");
     $strobe("nd3i     VB     entering OCA ( -1.000  V .. 1.000  V )   at %7.4r  %M", $abstime );
     $fwrite(outfile,"nd3i     VB     entering OCA ( -1.000  V .. 1.000  V )   at %7.4r  %M\n", $abstime );
     VB_retc=0;
     $fclose(outfile);
   end

end // analog
endmodule // nd3i

// Verilog-A OC Watch for device nmma Parameters  VGS VGD VDS VDB VSB
module nmma_ahdl(D,G,S,B);
parameter tstep_occ=100n;
inout D,G,S,B;
electrical D,G,S,B;

integer outfile;
real V_S_B;
real V_D_B;
real V_D_S;
real V_G_D;
real V_G_S;
real VGS;
integer VGS_retc;
real VGD;
integer VGD_retc;
real VDS;
integer VDS_retc;
real VDB;
integer VDB_retc;
real VSB;
integer VSB_retc;

analog begin

   $bound_step( tstep_occ );
   @(initial_step) begin
      VGS_retc=0;
      VGD_retc=0;
      VDS_retc=0;
      VDB_retc=0;
      VSB_retc=0;
   end
   V_S_B = V(S,B);
   V_D_B = V(D,B);
   V_D_S = V(D,S);
   V_G_D = V(G,D);
   V_G_S = V(G,S);

//      VGS
   VGS = V_G_S;
   if((VGS < -10) && (!VGS_retc))
   begin
     outfile=$fopen("./occ.err","a");
     $strobe("nmma     VGS    leaving  OCA ( < -10.000  V )            at %7.4r  %M", $abstime );
     $fwrite(outfile,"nmma     VGS    leaving  OCA ( < -10.000  V )            at %7.4r  %M\n", $abstime );
     VGS_retc=1;
     $fclose(outfile);
   end
   if((VGS > 10) && (!VGS_retc))
   begin
     outfile=$fopen("./occ.err","a");
     $strobe("nmma     VGS    leaving  OCA ( > 10.000  V )             at %7.4r  %M", $abstime );
     $fwrite(outfile,"nmma     VGS    leaving  OCA ( > 10.000  V )             at %7.4r  %M\n", $abstime );
     VGS_retc=1;
     $fclose(outfile);
   end
   if((VGS > -10) && (VGS < 10) && (VGS_retc))
   begin
     outfile=$fopen("./occ.err","a");
     $strobe("nmma     VGS    entering OCA ( -10.000  V .. 10.000  V ) at %7.4r  %M", $abstime );
     $fwrite(outfile,"nmma     VGS    entering OCA ( -10.000  V .. 10.000  V ) at %7.4r  %M\n", $abstime );
     VGS_retc=0;
     $fclose(outfile);
   end

//      VGD
   VGD = V_G_D;
   if((VGD < -10) && (!VGD_retc))
   begin
     outfile=$fopen("./occ.err","a");
     $strobe("nmma     VGD    leaving  OCA ( < -10.000  V )            at %7.4r  %M", $abstime );
     $fwrite(outfile,"nmma     VGD    leaving  OCA ( < -10.000  V )            at %7.4r  %M\n", $abstime );
     VGD_retc=1;
     $fclose(outfile);
   end
   if((VGD > 10) && (!VGD_retc))
   begin
     outfile=$fopen("./occ.err","a");
     $strobe("nmma     VGD    leaving  OCA ( > 10.000  V )             at %7.4r  %M", $abstime );
     $fwrite(outfile,"nmma     VGD    leaving  OCA ( > 10.000  V )             at %7.4r  %M\n", $abstime );
     VGD_retc=1;
     $fclose(outfile);
   end
   if((VGD > -10) && (VGD < 10) && (VGD_retc))
   begin
     outfile=$fopen("./occ.err","a");
     $strobe("nmma     VGD    entering OCA ( -10.000  V .. 10.000  V ) at %7.4r  %M", $abstime );
     $fwrite(outfile,"nmma     VGD    entering OCA ( -10.000  V .. 10.000  V ) at %7.4r  %M\n", $abstime );
     VGD_retc=0;
     $fclose(outfile);
   end

//      VDS
   VDS = V_D_S;
   if((VDS < -10) && (!VDS_retc))
   begin
     outfile=$fopen("./occ.err","a");
     $strobe("nmma     VDS    leaving  OCA ( < -10.000  V )            at %7.4r  %M", $abstime );
     $fwrite(outfile,"nmma     VDS    leaving  OCA ( < -10.000  V )            at %7.4r  %M\n", $abstime );
     VDS_retc=1;
     $fclose(outfile);
   end
   if((VDS > 10) && (!VDS_retc))
   begin
     outfile=$fopen("./occ.err","a");
     $strobe("nmma     VDS    leaving  OCA ( > 10.000  V )             at %7.4r  %M", $abstime );
     $fwrite(outfile,"nmma     VDS    leaving  OCA ( > 10.000  V )             at %7.4r  %M\n", $abstime );
     VDS_retc=1;
     $fclose(outfile);
   end
   if((VDS > -10) && (VDS < 10) && (VDS_retc))
   begin
     outfile=$fopen("./occ.err","a");
     $strobe("nmma     VDS    entering OCA ( -10.000  V .. 10.000  V ) at %7.4r  %M", $abstime );
     $fwrite(outfile,"nmma     VDS    entering OCA ( -10.000  V .. 10.000  V ) at %7.4r  %M\n", $abstime );
     VDS_retc=0;
     $fclose(outfile);
   end

//      VDB
   VDB = V_D_B;
   if((VDB < -0.1) && (!VDB_retc))
   begin
     outfile=$fopen("./occ.err","a");
     $strobe("nmma     VDB    leaving  OCA ( < -0.100  V )             at %7.4r  %M", $abstime );
     $fwrite(outfile,"nmma     VDB    leaving  OCA ( < -0.100  V )             at %7.4r  %M\n", $abstime );
     VDB_retc=1;
     $fclose(outfile);
   end
   if((VDB > 10) && (!VDB_retc))
   begin
     outfile=$fopen("./occ.err","a");
     $strobe("nmma     VDB    leaving  OCA ( > 10.000  V )             at %7.4r  %M", $abstime );
     $fwrite(outfile,"nmma     VDB    leaving  OCA ( > 10.000  V )             at %7.4r  %M\n", $abstime );
     VDB_retc=1;
     $fclose(outfile);
   end
   if((VDB > -0.1) && (VDB < 10) && (VDB_retc))
   begin
     outfile=$fopen("./occ.err","a");
     $strobe("nmma     VDB    entering OCA ( -0.100  V .. 10.000  V )  at %7.4r  %M", $abstime );
     $fwrite(outfile,"nmma     VDB    entering OCA ( -0.100  V .. 10.000  V )  at %7.4r  %M\n", $abstime );
     VDB_retc=0;
     $fclose(outfile);
   end

//      VSB
   VSB = V_S_B;
   if((VSB < -0.1) && (!VSB_retc))
   begin
     outfile=$fopen("./occ.err","a");
     $strobe("nmma     VSB    leaving  OCA ( < -0.100  V )             at %7.4r  %M", $abstime );
     $fwrite(outfile,"nmma     VSB    leaving  OCA ( < -0.100  V )             at %7.4r  %M\n", $abstime );
     VSB_retc=1;
     $fclose(outfile);
   end
   if((VSB > 10) && (!VSB_retc))
   begin
     outfile=$fopen("./occ.err","a");
     $strobe("nmma     VSB    leaving  OCA ( > 10.000  V )             at %7.4r  %M", $abstime );
     $fwrite(outfile,"nmma     VSB    leaving  OCA ( > 10.000  V )             at %7.4r  %M\n", $abstime );
     VSB_retc=1;
     $fclose(outfile);
   end
   if((VSB > -0.1) && (VSB < 10) && (VSB_retc))
   begin
     outfile=$fopen("./occ.err","a");
     $strobe("nmma     VSB    entering OCA ( -0.100  V .. 10.000  V )  at %7.4r  %M", $abstime );
     $fwrite(outfile,"nmma     VSB    entering OCA ( -0.100  V .. 10.000  V )  at %7.4r  %M\n", $abstime );
     VSB_retc=0;
     $fclose(outfile);
   end

end // analog
endmodule // nmma

// Verilog-A OC Watch for device nedi Parameters  VGS VGD VDS VDpsub VSpsub
module nedi_ahdl(D,G,S,B);
parameter tstep_occ=100n;
inout D,G,S,B;
electrical D,G,S,B;

integer outfile;
real V_S;
real V_D;
real V_D_S;
real V_G_D;
real V_G_S;
real VGS;
integer VGS_retc;
real VGD;
integer VGD_retc;
real VDS;
integer VDS_retc;
real VDpsub;
integer VDpsub_retc;
real VSpsub;
integer VSpsub_retc;

analog begin

   $bound_step( tstep_occ );
   @(initial_step) begin
      VGS_retc=0;
      VGD_retc=0;
      VDS_retc=0;
      VDpsub_retc=0;
      VSpsub_retc=0;
   end
   V_S = V(S);
   V_D = V(D);
   V_D_S = V(D,S);
   V_G_D = V(G,D);
   V_G_S = V(G,S);

//      VGS
   VGS = V_G_S;
   if((VGS < -18) && (!VGS_retc))
   begin
     outfile=$fopen("./occ.err","a");
     $strobe("nedi     VGS    leaving  OCA ( < -18.000  V )            at %7.4r  %M", $abstime );
     $fwrite(outfile,"nedi     VGS    leaving  OCA ( < -18.000  V )            at %7.4r  %M\n", $abstime );
     VGS_retc=1;
     $fclose(outfile);
   end
   if((VGS > 18) && (!VGS_retc))
   begin
     outfile=$fopen("./occ.err","a");
     $strobe("nedi     VGS    leaving  OCA ( > 18.000  V )             at %7.4r  %M", $abstime );
     $fwrite(outfile,"nedi     VGS    leaving  OCA ( > 18.000  V )             at %7.4r  %M\n", $abstime );
     VGS_retc=1;
     $fclose(outfile);
   end
   if((VGS > -18) && (VGS < 18) && (VGS_retc))
   begin
     outfile=$fopen("./occ.err","a");
     $strobe("nedi     VGS    entering OCA ( -18.000  V .. 18.000  V ) at %7.4r  %M", $abstime );
     $fwrite(outfile,"nedi     VGS    entering OCA ( -18.000  V .. 18.000  V ) at %7.4r  %M\n", $abstime );
     VGS_retc=0;
     $fclose(outfile);
   end

//      VGD
   VGD = V_G_D;
   if((VGD < -40) && (!VGD_retc))
   begin
     outfile=$fopen("./occ.err","a");
     $strobe("nedi     VGD    leaving  OCA ( < -40.000  V )            at %7.4r  %M", $abstime );
     $fwrite(outfile,"nedi     VGD    leaving  OCA ( < -40.000  V )            at %7.4r  %M\n", $abstime );
     VGD_retc=1;
     $fclose(outfile);
   end
   if((VGD > 18) && (!VGD_retc))
   begin
     outfile=$fopen("./occ.err","a");
     $strobe("nedi     VGD    leaving  OCA ( > 18.000  V )             at %7.4r  %M", $abstime );
     $fwrite(outfile,"nedi     VGD    leaving  OCA ( > 18.000  V )             at %7.4r  %M\n", $abstime );
     VGD_retc=1;
     $fclose(outfile);
   end
   if((VGD > -40) && (VGD < 18) && (VGD_retc))
   begin
     outfile=$fopen("./occ.err","a");
     $strobe("nedi     VGD    entering OCA ( -40.000  V .. 18.000  V ) at %7.4r  %M", $abstime );
     $fwrite(outfile,"nedi     VGD    entering OCA ( -40.000  V .. 18.000  V ) at %7.4r  %M\n", $abstime );
     VGD_retc=0;
     $fclose(outfile);
   end

//      VDS
   VDS = V_D_S;
   if((VDS < -0.1) && (!VDS_retc))
   begin
     outfile=$fopen("./occ.err","a");
     $strobe("nedi     VDS    leaving  OCA ( < -0.100  V )             at %7.4r  %M", $abstime );
     $fwrite(outfile,"nedi     VDS    leaving  OCA ( < -0.100  V )             at %7.4r  %M\n", $abstime );
     VDS_retc=1;
     $fclose(outfile);
   end
   if((VDS > 40) && (!VDS_retc))
   begin
     outfile=$fopen("./occ.err","a");
     $strobe("nedi     VDS    leaving  OCA ( > 40.000  V )             at %7.4r  %M", $abstime );
     $fwrite(outfile,"nedi     VDS    leaving  OCA ( > 40.000  V )             at %7.4r  %M\n", $abstime );
     VDS_retc=1;
     $fclose(outfile);
   end
   if((VDS > -0.1) && (VDS < 40) && (VDS_retc))
   begin
     outfile=$fopen("./occ.err","a");
     $strobe("nedi     VDS    entering OCA ( -0.100  V .. 40.000  V )  at %7.4r  %M", $abstime );
     $fwrite(outfile,"nedi     VDS    entering OCA ( -0.100  V .. 40.000  V )  at %7.4r  %M\n", $abstime );
     VDS_retc=0;
     $fclose(outfile);
   end

//      VDpsub
   VDpsub = V_D;
   if((VDpsub < -0.1) && (!VDpsub_retc))
   begin
     outfile=$fopen("./occ.err","a");
     $strobe("nedi     VDpsub leaving  OCA ( < -0.100  V )             at %7.4r  %M", $abstime );
     $fwrite(outfile,"nedi     VDpsub leaving  OCA ( < -0.100  V )             at %7.4r  %M\n", $abstime );
     VDpsub_retc=1;
     $fclose(outfile);
   end
   if((VDpsub > 40) && (!VDpsub_retc))
   begin
     outfile=$fopen("./occ.err","a");
     $strobe("nedi     VDpsub leaving  OCA ( > 40.000  V )             at %7.4r  %M", $abstime );
     $fwrite(outfile,"nedi     VDpsub leaving  OCA ( > 40.000  V )             at %7.4r  %M\n", $abstime );
     VDpsub_retc=1;
     $fclose(outfile);
   end
   if((VDpsub > -0.1) && (VDpsub < 40) && (VDpsub_retc))
   begin
     outfile=$fopen("./occ.err","a");
     $strobe("nedi     VDpsub entering OCA ( -0.100  V .. 40.000  V )  at %7.4r  %M", $abstime );
     $fwrite(outfile,"nedi     VDpsub entering OCA ( -0.100  V .. 40.000  V )  at %7.4r  %M\n", $abstime );
     VDpsub_retc=0;
     $fclose(outfile);
   end

//      VSpsub
   VSpsub = V_S;
   if((VSpsub < -0.1) && (!VSpsub_retc))
   begin
     outfile=$fopen("./occ.err","a");
     $strobe("nedi     VSpsub leaving  OCA ( < -0.100  V )             at %7.4r  %M", $abstime );
     $fwrite(outfile,"nedi     VSpsub leaving  OCA ( < -0.100  V )             at %7.4r  %M\n", $abstime );
     VSpsub_retc=1;
     $fclose(outfile);
   end
   if((VSpsub > 40) && (!VSpsub_retc))
   begin
     outfile=$fopen("./occ.err","a");
     $strobe("nedi     VSpsub leaving  OCA ( > 40.000  V )             at %7.4r  %M", $abstime );
     $fwrite(outfile,"nedi     VSpsub leaving  OCA ( > 40.000  V )             at %7.4r  %M\n", $abstime );
     VSpsub_retc=1;
     $fclose(outfile);
   end
   if((VSpsub > -0.1) && (VSpsub < 40) && (VSpsub_retc))
   begin
     outfile=$fopen("./occ.err","a");
     $strobe("nedi     VSpsub entering OCA ( -0.100  V .. 40.000  V )  at %7.4r  %M", $abstime );
     $fwrite(outfile,"nedi     VSpsub entering OCA ( -0.100  V .. 40.000  V )  at %7.4r  %M\n", $abstime );
     VSpsub_retc=0;
     $fclose(outfile);
   end

end // analog
endmodule // nedi

// Verilog-A OC Watch for device nedia Parameters  VGS VGD VDS VDpsub VSpsub
module nedia_ahdl(D,G,S,B);
parameter tstep_occ=100n;
inout D,G,S,B;
electrical D,G,S,B;

integer outfile;
real V_S;
real V_D;
real V_D_S;
real V_G_D;
real V_G_S;
real VGS;
integer VGS_retc;
real VGD;
integer VGD_retc;
real VDS;
integer VDS_retc;
real VDpsub;
integer VDpsub_retc;
real VSpsub;
integer VSpsub_retc;

analog begin

   $bound_step( tstep_occ );
   @(initial_step) begin
      VGS_retc=0;
      VGD_retc=0;
      VDS_retc=0;
      VDpsub_retc=0;
      VSpsub_retc=0;
   end
   V_S = V(S);
   V_D = V(D);
   V_D_S = V(D,S);
   V_G_D = V(G,D);
   V_G_S = V(G,S);

//      VGS
   VGS = V_G_S;
   if((VGS < -18) && (!VGS_retc))
   begin
     outfile=$fopen("./occ.err","a");
     $strobe("nedia    VGS    leaving  OCA ( < -18.000  V )            at %7.4r  %M", $abstime );
     $fwrite(outfile,"nedia    VGS    leaving  OCA ( < -18.000  V )            at %7.4r  %M\n", $abstime );
     VGS_retc=1;
     $fclose(outfile);
   end
   if((VGS > 18) && (!VGS_retc))
   begin
     outfile=$fopen("./occ.err","a");
     $strobe("nedia    VGS    leaving  OCA ( > 18.000  V )             at %7.4r  %M", $abstime );
     $fwrite(outfile,"nedia    VGS    leaving  OCA ( > 18.000  V )             at %7.4r  %M\n", $abstime );
     VGS_retc=1;
     $fclose(outfile);
   end
   if((VGS > -18) && (VGS < 18) && (VGS_retc))
   begin
     outfile=$fopen("./occ.err","a");
     $strobe("nedia    VGS    entering OCA ( -18.000  V .. 18.000  V ) at %7.4r  %M", $abstime );
     $fwrite(outfile,"nedia    VGS    entering OCA ( -18.000  V .. 18.000  V ) at %7.4r  %M\n", $abstime );
     VGS_retc=0;
     $fclose(outfile);
   end

//      VGD
   VGD = V_G_D;
   if((VGD < -45) && (!VGD_retc))
   begin
     outfile=$fopen("./occ.err","a");
     $strobe("nedia    VGD    leaving  OCA ( < -45.000  V )            at %7.4r  %M", $abstime );
     $fwrite(outfile,"nedia    VGD    leaving  OCA ( < -45.000  V )            at %7.4r  %M\n", $abstime );
     VGD_retc=1;
     $fclose(outfile);
   end
   if((VGD > 18) && (!VGD_retc))
   begin
     outfile=$fopen("./occ.err","a");
     $strobe("nedia    VGD    leaving  OCA ( > 18.000  V )             at %7.4r  %M", $abstime );
     $fwrite(outfile,"nedia    VGD    leaving  OCA ( > 18.000  V )             at %7.4r  %M\n", $abstime );
     VGD_retc=1;
     $fclose(outfile);
   end
   if((VGD > -45) && (VGD < 18) && (VGD_retc))
   begin
     outfile=$fopen("./occ.err","a");
     $strobe("nedia    VGD    entering OCA ( -45.000  V .. 18.000  V ) at %7.4r  %M", $abstime );
     $fwrite(outfile,"nedia    VGD    entering OCA ( -45.000  V .. 18.000  V ) at %7.4r  %M\n", $abstime );
     VGD_retc=0;
     $fclose(outfile);
   end

//      VDS
   VDS = V_D_S;
   if((VDS < -0.1) && (!VDS_retc))
   begin
     outfile=$fopen("./occ.err","a");
     $strobe("nedia    VDS    leaving  OCA ( < -0.100  V )             at %7.4r  %M", $abstime );
     $fwrite(outfile,"nedia    VDS    leaving  OCA ( < -0.100  V )             at %7.4r  %M\n", $abstime );
     VDS_retc=1;
     $fclose(outfile);
   end
   if((VDS > 45) && (!VDS_retc))
   begin
     outfile=$fopen("./occ.err","a");
     $strobe("nedia    VDS    leaving  OCA ( > 45.000  V )             at %7.4r  %M", $abstime );
     $fwrite(outfile,"nedia    VDS    leaving  OCA ( > 45.000  V )             at %7.4r  %M\n", $abstime );
     VDS_retc=1;
     $fclose(outfile);
   end
   if((VDS > -0.1) && (VDS < 45) && (VDS_retc))
   begin
     outfile=$fopen("./occ.err","a");
     $strobe("nedia    VDS    entering OCA ( -0.100  V .. 45.000  V )  at %7.4r  %M", $abstime );
     $fwrite(outfile,"nedia    VDS    entering OCA ( -0.100  V .. 45.000  V )  at %7.4r  %M\n", $abstime );
     VDS_retc=0;
     $fclose(outfile);
   end

//      VDpsub
   VDpsub = V_D;
   if((VDpsub < -0.1) && (!VDpsub_retc))
   begin
     outfile=$fopen("./occ.err","a");
     $strobe("nedia    VDpsub leaving  OCA ( < -0.100  V )             at %7.4r  %M", $abstime );
     $fwrite(outfile,"nedia    VDpsub leaving  OCA ( < -0.100  V )             at %7.4r  %M\n", $abstime );
     VDpsub_retc=1;
     $fclose(outfile);
   end
   if((VDpsub > 45) && (!VDpsub_retc))
   begin
     outfile=$fopen("./occ.err","a");
     $strobe("nedia    VDpsub leaving  OCA ( > 45.000  V )             at %7.4r  %M", $abstime );
     $fwrite(outfile,"nedia    VDpsub leaving  OCA ( > 45.000  V )             at %7.4r  %M\n", $abstime );
     VDpsub_retc=1;
     $fclose(outfile);
   end
   if((VDpsub > -0.1) && (VDpsub < 45) && (VDpsub_retc))
   begin
     outfile=$fopen("./occ.err","a");
     $strobe("nedia    VDpsub entering OCA ( -0.100  V .. 45.000  V )  at %7.4r  %M", $abstime );
     $fwrite(outfile,"nedia    VDpsub entering OCA ( -0.100  V .. 45.000  V )  at %7.4r  %M\n", $abstime );
     VDpsub_retc=0;
     $fclose(outfile);
   end

//      VSpsub
   VSpsub = V_S;
   if((VSpsub < -0.1) && (!VSpsub_retc))
   begin
     outfile=$fopen("./occ.err","a");
     $strobe("nedia    VSpsub leaving  OCA ( < -0.100  V )             at %7.4r  %M", $abstime );
     $fwrite(outfile,"nedia    VSpsub leaving  OCA ( < -0.100  V )             at %7.4r  %M\n", $abstime );
     VSpsub_retc=1;
     $fclose(outfile);
   end
   if((VSpsub > 45) && (!VSpsub_retc))
   begin
     outfile=$fopen("./occ.err","a");
     $strobe("nedia    VSpsub leaving  OCA ( > 45.000  V )             at %7.4r  %M", $abstime );
     $fwrite(outfile,"nedia    VSpsub leaving  OCA ( > 45.000  V )             at %7.4r  %M\n", $abstime );
     VSpsub_retc=1;
     $fclose(outfile);
   end
   if((VSpsub > -0.1) && (VSpsub < 45) && (VSpsub_retc))
   begin
     outfile=$fopen("./occ.err","a");
     $strobe("nedia    VSpsub entering OCA ( -0.100  V .. 45.000  V )  at %7.4r  %M", $abstime );
     $fwrite(outfile,"nedia    VSpsub entering OCA ( -0.100  V .. 45.000  V )  at %7.4r  %M\n", $abstime );
     VSpsub_retc=0;
     $fclose(outfile);
   end

end // analog
endmodule // nedia

// Verilog-A OC Watch for device pe Parameters  VGS VGD VDS VDB VSB VB
module pe_ahdl(D,G,S,B);
parameter tstep_occ=100n;
inout D,G,S,B;
electrical D,G,S,B;

integer outfile;
real V_B;
real V_S_B;
real V_D_B;
real V_D_S;
real V_G_D;
real V_G_S;
real VGS;
integer VGS_retc;
real VGD;
integer VGD_retc;
real VDS;
integer VDS_retc;
real VDB;
integer VDB_retc;
real VSB;
integer VSB_retc;
real VB;
integer VB_retc;

analog begin

   $bound_step( tstep_occ );
   @(initial_step) begin
      VGS_retc=0;
      VGD_retc=0;
      VDS_retc=0;
      VDB_retc=0;
      VSB_retc=0;
      VB_retc=0;
   end
   V_B = V(B);
   V_S_B = V(S,B);
   V_D_B = V(D,B);
   V_D_S = V(D,S);
   V_G_D = V(G,D);
   V_G_S = V(G,S);

//      VGS
   VGS = V_G_S;
   if((VGS < -1.98) && (!VGS_retc))
   begin
     outfile=$fopen("./occ.err","a");
     $strobe("pe       VGS    leaving  OCA ( < -1.980  V )             at %7.4r  %M", $abstime );
     $fwrite(outfile,"pe       VGS    leaving  OCA ( < -1.980  V )             at %7.4r  %M\n", $abstime );
     VGS_retc=1;
     $fclose(outfile);
   end
   if((VGS > 1.98) && (!VGS_retc))
   begin
     outfile=$fopen("./occ.err","a");
     $strobe("pe       VGS    leaving  OCA ( > 1.980  V )              at %7.4r  %M", $abstime );
     $fwrite(outfile,"pe       VGS    leaving  OCA ( > 1.980  V )              at %7.4r  %M\n", $abstime );
     VGS_retc=1;
     $fclose(outfile);
   end
   if((VGS > -1.98) && (VGS < 1.98) && (VGS_retc))
   begin
     outfile=$fopen("./occ.err","a");
     $strobe("pe       VGS    entering OCA ( -1.980  V .. 1.980  V )   at %7.4r  %M", $abstime );
     $fwrite(outfile,"pe       VGS    entering OCA ( -1.980  V .. 1.980  V )   at %7.4r  %M\n", $abstime );
     VGS_retc=0;
     $fclose(outfile);
   end

//      VGD
   VGD = V_G_D;
   if((VGD < -1.98) && (!VGD_retc))
   begin
     outfile=$fopen("./occ.err","a");
     $strobe("pe       VGD    leaving  OCA ( < -1.980  V )             at %7.4r  %M", $abstime );
     $fwrite(outfile,"pe       VGD    leaving  OCA ( < -1.980  V )             at %7.4r  %M\n", $abstime );
     VGD_retc=1;
     $fclose(outfile);
   end
   if((VGD > 1.98) && (!VGD_retc))
   begin
     outfile=$fopen("./occ.err","a");
     $strobe("pe       VGD    leaving  OCA ( > 1.980  V )              at %7.4r  %M", $abstime );
     $fwrite(outfile,"pe       VGD    leaving  OCA ( > 1.980  V )              at %7.4r  %M\n", $abstime );
     VGD_retc=1;
     $fclose(outfile);
   end
   if((VGD > -1.98) && (VGD < 1.98) && (VGD_retc))
   begin
     outfile=$fopen("./occ.err","a");
     $strobe("pe       VGD    entering OCA ( -1.980  V .. 1.980  V )   at %7.4r  %M", $abstime );
     $fwrite(outfile,"pe       VGD    entering OCA ( -1.980  V .. 1.980  V )   at %7.4r  %M\n", $abstime );
     VGD_retc=0;
     $fclose(outfile);
   end

//      VDS
   VDS = V_D_S;
   if((VDS < -1.98) && (!VDS_retc))
   begin
     outfile=$fopen("./occ.err","a");
     $strobe("pe       VDS    leaving  OCA ( < -1.980  V )             at %7.4r  %M", $abstime );
     $fwrite(outfile,"pe       VDS    leaving  OCA ( < -1.980  V )             at %7.4r  %M\n", $abstime );
     VDS_retc=1;
     $fclose(outfile);
   end
   if((VDS > 1.98) && (!VDS_retc))
   begin
     outfile=$fopen("./occ.err","a");
     $strobe("pe       VDS    leaving  OCA ( > 1.980  V )              at %7.4r  %M", $abstime );
     $fwrite(outfile,"pe       VDS    leaving  OCA ( > 1.980  V )              at %7.4r  %M\n", $abstime );
     VDS_retc=1;
     $fclose(outfile);
   end
   if((VDS > -1.98) && (VDS < 1.98) && (VDS_retc))
   begin
     outfile=$fopen("./occ.err","a");
     $strobe("pe       VDS    entering OCA ( -1.980  V .. 1.980  V )   at %7.4r  %M", $abstime );
     $fwrite(outfile,"pe       VDS    entering OCA ( -1.980  V .. 1.980  V )   at %7.4r  %M\n", $abstime );
     VDS_retc=0;
     $fclose(outfile);
   end

//      VDB
   VDB = V_D_B;
   if((VDB < -1.98) && (!VDB_retc))
   begin
     outfile=$fopen("./occ.err","a");
     $strobe("pe       VDB    leaving  OCA ( < -1.980  V )             at %7.4r  %M", $abstime );
     $fwrite(outfile,"pe       VDB    leaving  OCA ( < -1.980  V )             at %7.4r  %M\n", $abstime );
     VDB_retc=1;
     $fclose(outfile);
   end
   if((VDB > 0.1) && (!VDB_retc))
   begin
     outfile=$fopen("./occ.err","a");
     $strobe("pe       VDB    leaving  OCA ( > 0.100  V )              at %7.4r  %M", $abstime );
     $fwrite(outfile,"pe       VDB    leaving  OCA ( > 0.100  V )              at %7.4r  %M\n", $abstime );
     VDB_retc=1;
     $fclose(outfile);
   end
   if((VDB > -1.98) && (VDB < 0.1) && (VDB_retc))
   begin
     outfile=$fopen("./occ.err","a");
     $strobe("pe       VDB    entering OCA ( -1.980  V .. 0.100  V )   at %7.4r  %M", $abstime );
     $fwrite(outfile,"pe       VDB    entering OCA ( -1.980  V .. 0.100  V )   at %7.4r  %M\n", $abstime );
     VDB_retc=0;
     $fclose(outfile);
   end

//      VSB
   VSB = V_S_B;
   if((VSB < -1.98) && (!VSB_retc))
   begin
     outfile=$fopen("./occ.err","a");
     $strobe("pe       VSB    leaving  OCA ( < -1.980  V )             at %7.4r  %M", $abstime );
     $fwrite(outfile,"pe       VSB    leaving  OCA ( < -1.980  V )             at %7.4r  %M\n", $abstime );
     VSB_retc=1;
     $fclose(outfile);
   end
   if((VSB > 0.1) && (!VSB_retc))
   begin
     outfile=$fopen("./occ.err","a");
     $strobe("pe       VSB    leaving  OCA ( > 0.100  V )              at %7.4r  %M", $abstime );
     $fwrite(outfile,"pe       VSB    leaving  OCA ( > 0.100  V )              at %7.4r  %M\n", $abstime );
     VSB_retc=1;
     $fclose(outfile);
   end
   if((VSB > -1.98) && (VSB < 0.1) && (VSB_retc))
   begin
     outfile=$fopen("./occ.err","a");
     $strobe("pe       VSB    entering OCA ( -1.980  V .. 0.100  V )   at %7.4r  %M", $abstime );
     $fwrite(outfile,"pe       VSB    entering OCA ( -1.980  V .. 0.100  V )   at %7.4r  %M\n", $abstime );
     VSB_retc=0;
     $fclose(outfile);
   end

//      VB
   VB = V_B;
   if((VB < -0.1) && (!VB_retc))
   begin
     outfile=$fopen("./occ.err","a");
     $strobe("pe       VB     leaving  OCA ( < -0.100  V )             at %7.4r  %M", $abstime );
     $fwrite(outfile,"pe       VB     leaving  OCA ( < -0.100  V )             at %7.4r  %M\n", $abstime );
     VB_retc=1;
     $fclose(outfile);
   end
   if((VB > 1.98) && (!VB_retc))
   begin
     outfile=$fopen("./occ.err","a");
     $strobe("pe       VB     leaving  OCA ( > 1.980  V )              at %7.4r  %M", $abstime );
     $fwrite(outfile,"pe       VB     leaving  OCA ( > 1.980  V )              at %7.4r  %M\n", $abstime );
     VB_retc=1;
     $fclose(outfile);
   end
   if((VB > -0.1) && (VB < 1.98) && (VB_retc))
   begin
     outfile=$fopen("./occ.err","a");
     $strobe("pe       VB     entering OCA ( -0.100  V .. 1.980  V )   at %7.4r  %M", $abstime );
     $fwrite(outfile,"pe       VB     entering OCA ( -0.100  V .. 1.980  V )   at %7.4r  %M\n", $abstime );
     VB_retc=0;
     $fclose(outfile);
   end

end // analog
endmodule // pe

// Verilog-A OC Watch for device pei Parameters  VGS VGD VDS VDB VSB VB
module pei_ahdl(D,G,S,B);
parameter tstep_occ=100n;
inout D,G,S,B;
electrical D,G,S,B;

integer outfile;
real V_B;
real V_S_B;
real V_D_B;
real V_D_S;
real V_G_D;
real V_G_S;
real VGS;
integer VGS_retc;
real VGD;
integer VGD_retc;
real VDS;
integer VDS_retc;
real VDB;
integer VDB_retc;
real VSB;
integer VSB_retc;
real VB;
integer VB_retc;

analog begin

   $bound_step( tstep_occ );
   @(initial_step) begin
      VGS_retc=0;
      VGD_retc=0;
      VDS_retc=0;
      VDB_retc=0;
      VSB_retc=0;
      VB_retc=0;
   end
   V_B = V(B);
   V_S_B = V(S,B);
   V_D_B = V(D,B);
   V_D_S = V(D,S);
   V_G_D = V(G,D);
   V_G_S = V(G,S);

//      VGS
   VGS = V_G_S;
   if((VGS < -1.98) && (!VGS_retc))
   begin
     outfile=$fopen("./occ.err","a");
     $strobe("pei      VGS    leaving  OCA ( < -1.980  V )             at %7.4r  %M", $abstime );
     $fwrite(outfile,"pei      VGS    leaving  OCA ( < -1.980  V )             at %7.4r  %M\n", $abstime );
     VGS_retc=1;
     $fclose(outfile);
   end
   if((VGS > 1.98) && (!VGS_retc))
   begin
     outfile=$fopen("./occ.err","a");
     $strobe("pei      VGS    leaving  OCA ( > 1.980  V )              at %7.4r  %M", $abstime );
     $fwrite(outfile,"pei      VGS    leaving  OCA ( > 1.980  V )              at %7.4r  %M\n", $abstime );
     VGS_retc=1;
     $fclose(outfile);
   end
   if((VGS > -1.98) && (VGS < 1.98) && (VGS_retc))
   begin
     outfile=$fopen("./occ.err","a");
     $strobe("pei      VGS    entering OCA ( -1.980  V .. 1.980  V )   at %7.4r  %M", $abstime );
     $fwrite(outfile,"pei      VGS    entering OCA ( -1.980  V .. 1.980  V )   at %7.4r  %M\n", $abstime );
     VGS_retc=0;
     $fclose(outfile);
   end

//      VGD
   VGD = V_G_D;
   if((VGD < -1.98) && (!VGD_retc))
   begin
     outfile=$fopen("./occ.err","a");
     $strobe("pei      VGD    leaving  OCA ( < -1.980  V )             at %7.4r  %M", $abstime );
     $fwrite(outfile,"pei      VGD    leaving  OCA ( < -1.980  V )             at %7.4r  %M\n", $abstime );
     VGD_retc=1;
     $fclose(outfile);
   end
   if((VGD > 1.98) && (!VGD_retc))
   begin
     outfile=$fopen("./occ.err","a");
     $strobe("pei      VGD    leaving  OCA ( > 1.980  V )              at %7.4r  %M", $abstime );
     $fwrite(outfile,"pei      VGD    leaving  OCA ( > 1.980  V )              at %7.4r  %M\n", $abstime );
     VGD_retc=1;
     $fclose(outfile);
   end
   if((VGD > -1.98) && (VGD < 1.98) && (VGD_retc))
   begin
     outfile=$fopen("./occ.err","a");
     $strobe("pei      VGD    entering OCA ( -1.980  V .. 1.980  V )   at %7.4r  %M", $abstime );
     $fwrite(outfile,"pei      VGD    entering OCA ( -1.980  V .. 1.980  V )   at %7.4r  %M\n", $abstime );
     VGD_retc=0;
     $fclose(outfile);
   end

//      VDS
   VDS = V_D_S;
   if((VDS < -1.98) && (!VDS_retc))
   begin
     outfile=$fopen("./occ.err","a");
     $strobe("pei      VDS    leaving  OCA ( < -1.980  V )             at %7.4r  %M", $abstime );
     $fwrite(outfile,"pei      VDS    leaving  OCA ( < -1.980  V )             at %7.4r  %M\n", $abstime );
     VDS_retc=1;
     $fclose(outfile);
   end
   if((VDS > 1.98) && (!VDS_retc))
   begin
     outfile=$fopen("./occ.err","a");
     $strobe("pei      VDS    leaving  OCA ( > 1.980  V )              at %7.4r  %M", $abstime );
     $fwrite(outfile,"pei      VDS    leaving  OCA ( > 1.980  V )              at %7.4r  %M\n", $abstime );
     VDS_retc=1;
     $fclose(outfile);
   end
   if((VDS > -1.98) && (VDS < 1.98) && (VDS_retc))
   begin
     outfile=$fopen("./occ.err","a");
     $strobe("pei      VDS    entering OCA ( -1.980  V .. 1.980  V )   at %7.4r  %M", $abstime );
     $fwrite(outfile,"pei      VDS    entering OCA ( -1.980  V .. 1.980  V )   at %7.4r  %M\n", $abstime );
     VDS_retc=0;
     $fclose(outfile);
   end

//      VDB
   VDB = V_D_B;
   if((VDB < -1.98) && (!VDB_retc))
   begin
     outfile=$fopen("./occ.err","a");
     $strobe("pei      VDB    leaving  OCA ( < -1.980  V )             at %7.4r  %M", $abstime );
     $fwrite(outfile,"pei      VDB    leaving  OCA ( < -1.980  V )             at %7.4r  %M\n", $abstime );
     VDB_retc=1;
     $fclose(outfile);
   end
   if((VDB > 0.1) && (!VDB_retc))
   begin
     outfile=$fopen("./occ.err","a");
     $strobe("pei      VDB    leaving  OCA ( > 0.100  V )              at %7.4r  %M", $abstime );
     $fwrite(outfile,"pei      VDB    leaving  OCA ( > 0.100  V )              at %7.4r  %M\n", $abstime );
     VDB_retc=1;
     $fclose(outfile);
   end
   if((VDB > -1.98) && (VDB < 0.1) && (VDB_retc))
   begin
     outfile=$fopen("./occ.err","a");
     $strobe("pei      VDB    entering OCA ( -1.980  V .. 0.100  V )   at %7.4r  %M", $abstime );
     $fwrite(outfile,"pei      VDB    entering OCA ( -1.980  V .. 0.100  V )   at %7.4r  %M\n", $abstime );
     VDB_retc=0;
     $fclose(outfile);
   end

//      VSB
   VSB = V_S_B;
   if((VSB < -1.98) && (!VSB_retc))
   begin
     outfile=$fopen("./occ.err","a");
     $strobe("pei      VSB    leaving  OCA ( < -1.980  V )             at %7.4r  %M", $abstime );
     $fwrite(outfile,"pei      VSB    leaving  OCA ( < -1.980  V )             at %7.4r  %M\n", $abstime );
     VSB_retc=1;
     $fclose(outfile);
   end
   if((VSB > 0.1) && (!VSB_retc))
   begin
     outfile=$fopen("./occ.err","a");
     $strobe("pei      VSB    leaving  OCA ( > 0.100  V )              at %7.4r  %M", $abstime );
     $fwrite(outfile,"pei      VSB    leaving  OCA ( > 0.100  V )              at %7.4r  %M\n", $abstime );
     VSB_retc=1;
     $fclose(outfile);
   end
   if((VSB > -1.98) && (VSB < 0.1) && (VSB_retc))
   begin
     outfile=$fopen("./occ.err","a");
     $strobe("pei      VSB    entering OCA ( -1.980  V .. 0.100  V )   at %7.4r  %M", $abstime );
     $fwrite(outfile,"pei      VSB    entering OCA ( -1.980  V .. 0.100  V )   at %7.4r  %M\n", $abstime );
     VSB_retc=0;
     $fclose(outfile);
   end

//      VB
   VB = V_B;
   if((VB < -0.1) && (!VB_retc))
   begin
     outfile=$fopen("./occ.err","a");
     $strobe("pei      VB     leaving  OCA ( < -0.100  V )             at %7.4r  %M", $abstime );
     $fwrite(outfile,"pei      VB     leaving  OCA ( < -0.100  V )             at %7.4r  %M\n", $abstime );
     VB_retc=1;
     $fclose(outfile);
   end
   if((VB > 1.98) && (!VB_retc))
   begin
     outfile=$fopen("./occ.err","a");
     $strobe("pei      VB     leaving  OCA ( > 1.980  V )              at %7.4r  %M", $abstime );
     $fwrite(outfile,"pei      VB     leaving  OCA ( > 1.980  V )              at %7.4r  %M\n", $abstime );
     VB_retc=1;
     $fclose(outfile);
   end
   if((VB > -0.1) && (VB < 1.98) && (VB_retc))
   begin
     outfile=$fopen("./occ.err","a");
     $strobe("pei      VB     entering OCA ( -0.100  V .. 1.980  V )   at %7.4r  %M", $abstime );
     $fwrite(outfile,"pei      VB     entering OCA ( -0.100  V .. 1.980  V )   at %7.4r  %M\n", $abstime );
     VB_retc=0;
     $fclose(outfile);
   end

end // analog
endmodule // pei

// Verilog-A OC Watch for device pe3 Parameters  VGS VGD VDS VDB VSB VB
module pe3_ahdl(D,G,S,B);
parameter tstep_occ=100n;
inout D,G,S,B;
electrical D,G,S,B;

integer outfile;
real V_B;
real V_S_B;
real V_D_B;
real V_D_S;
real V_G_D;
real V_G_S;
real VGS;
integer VGS_retc;
real VGD;
integer VGD_retc;
real VDS;
integer VDS_retc;
real VDB;
integer VDB_retc;
real VSB;
integer VSB_retc;
real VB;
integer VB_retc;

analog begin

   $bound_step( tstep_occ );
   @(initial_step) begin
      VGS_retc=0;
      VGD_retc=0;
      VDS_retc=0;
      VDB_retc=0;
      VSB_retc=0;
      VB_retc=0;
   end
   V_B = V(B);
   V_S_B = V(S,B);
   V_D_B = V(D,B);
   V_D_S = V(D,S);
   V_G_D = V(G,D);
   V_G_S = V(G,S);

//      VGS
   VGS = V_G_S;
   if((VGS < -3.6) && (!VGS_retc))
   begin
     outfile=$fopen("./occ.err","a");
     $strobe("pe3      VGS    leaving  OCA ( < -3.600  V )             at %7.4r  %M", $abstime );
     $fwrite(outfile,"pe3      VGS    leaving  OCA ( < -3.600  V )             at %7.4r  %M\n", $abstime );
     VGS_retc=1;
     $fclose(outfile);
   end
   if((VGS > 3.6) && (!VGS_retc))
   begin
     outfile=$fopen("./occ.err","a");
     $strobe("pe3      VGS    leaving  OCA ( > 3.600  V )              at %7.4r  %M", $abstime );
     $fwrite(outfile,"pe3      VGS    leaving  OCA ( > 3.600  V )              at %7.4r  %M\n", $abstime );
     VGS_retc=1;
     $fclose(outfile);
   end
   if((VGS > -3.6) && (VGS < 3.6) && (VGS_retc))
   begin
     outfile=$fopen("./occ.err","a");
     $strobe("pe3      VGS    entering OCA ( -3.600  V .. 3.600  V )   at %7.4r  %M", $abstime );
     $fwrite(outfile,"pe3      VGS    entering OCA ( -3.600  V .. 3.600  V )   at %7.4r  %M\n", $abstime );
     VGS_retc=0;
     $fclose(outfile);
   end

//      VGD
   VGD = V_G_D;
   if((VGD < -3.6) && (!VGD_retc))
   begin
     outfile=$fopen("./occ.err","a");
     $strobe("pe3      VGD    leaving  OCA ( < -3.600  V )             at %7.4r  %M", $abstime );
     $fwrite(outfile,"pe3      VGD    leaving  OCA ( < -3.600  V )             at %7.4r  %M\n", $abstime );
     VGD_retc=1;
     $fclose(outfile);
   end
   if((VGD > 3.6) && (!VGD_retc))
   begin
     outfile=$fopen("./occ.err","a");
     $strobe("pe3      VGD    leaving  OCA ( > 3.600  V )              at %7.4r  %M", $abstime );
     $fwrite(outfile,"pe3      VGD    leaving  OCA ( > 3.600  V )              at %7.4r  %M\n", $abstime );
     VGD_retc=1;
     $fclose(outfile);
   end
   if((VGD > -3.6) && (VGD < 3.6) && (VGD_retc))
   begin
     outfile=$fopen("./occ.err","a");
     $strobe("pe3      VGD    entering OCA ( -3.600  V .. 3.600  V )   at %7.4r  %M", $abstime );
     $fwrite(outfile,"pe3      VGD    entering OCA ( -3.600  V .. 3.600  V )   at %7.4r  %M\n", $abstime );
     VGD_retc=0;
     $fclose(outfile);
   end

//      VDS
   VDS = V_D_S;
   if((VDS < -3.6) && (!VDS_retc))
   begin
     outfile=$fopen("./occ.err","a");
     $strobe("pe3      VDS    leaving  OCA ( < -3.600  V )             at %7.4r  %M", $abstime );
     $fwrite(outfile,"pe3      VDS    leaving  OCA ( < -3.600  V )             at %7.4r  %M\n", $abstime );
     VDS_retc=1;
     $fclose(outfile);
   end
   if((VDS > 3.6) && (!VDS_retc))
   begin
     outfile=$fopen("./occ.err","a");
     $strobe("pe3      VDS    leaving  OCA ( > 3.600  V )              at %7.4r  %M", $abstime );
     $fwrite(outfile,"pe3      VDS    leaving  OCA ( > 3.600  V )              at %7.4r  %M\n", $abstime );
     VDS_retc=1;
     $fclose(outfile);
   end
   if((VDS > -3.6) && (VDS < 3.6) && (VDS_retc))
   begin
     outfile=$fopen("./occ.err","a");
     $strobe("pe3      VDS    entering OCA ( -3.600  V .. 3.600  V )   at %7.4r  %M", $abstime );
     $fwrite(outfile,"pe3      VDS    entering OCA ( -3.600  V .. 3.600  V )   at %7.4r  %M\n", $abstime );
     VDS_retc=0;
     $fclose(outfile);
   end

//      VDB
   VDB = V_D_B;
   if((VDB < -3.6) && (!VDB_retc))
   begin
     outfile=$fopen("./occ.err","a");
     $strobe("pe3      VDB    leaving  OCA ( < -3.600  V )             at %7.4r  %M", $abstime );
     $fwrite(outfile,"pe3      VDB    leaving  OCA ( < -3.600  V )             at %7.4r  %M\n", $abstime );
     VDB_retc=1;
     $fclose(outfile);
   end
   if((VDB > 0.1) && (!VDB_retc))
   begin
     outfile=$fopen("./occ.err","a");
     $strobe("pe3      VDB    leaving  OCA ( > 0.100  V )              at %7.4r  %M", $abstime );
     $fwrite(outfile,"pe3      VDB    leaving  OCA ( > 0.100  V )              at %7.4r  %M\n", $abstime );
     VDB_retc=1;
     $fclose(outfile);
   end
   if((VDB > -3.6) && (VDB < 0.1) && (VDB_retc))
   begin
     outfile=$fopen("./occ.err","a");
     $strobe("pe3      VDB    entering OCA ( -3.600  V .. 0.100  V )   at %7.4r  %M", $abstime );
     $fwrite(outfile,"pe3      VDB    entering OCA ( -3.600  V .. 0.100  V )   at %7.4r  %M\n", $abstime );
     VDB_retc=0;
     $fclose(outfile);
   end

//      VSB
   VSB = V_S_B;
   if((VSB < -3.6) && (!VSB_retc))
   begin
     outfile=$fopen("./occ.err","a");
     $strobe("pe3      VSB    leaving  OCA ( < -3.600  V )             at %7.4r  %M", $abstime );
     $fwrite(outfile,"pe3      VSB    leaving  OCA ( < -3.600  V )             at %7.4r  %M\n", $abstime );
     VSB_retc=1;
     $fclose(outfile);
   end
   if((VSB > 0.1) && (!VSB_retc))
   begin
     outfile=$fopen("./occ.err","a");
     $strobe("pe3      VSB    leaving  OCA ( > 0.100  V )              at %7.4r  %M", $abstime );
     $fwrite(outfile,"pe3      VSB    leaving  OCA ( > 0.100  V )              at %7.4r  %M\n", $abstime );
     VSB_retc=1;
     $fclose(outfile);
   end
   if((VSB > -3.6) && (VSB < 0.1) && (VSB_retc))
   begin
     outfile=$fopen("./occ.err","a");
     $strobe("pe3      VSB    entering OCA ( -3.600  V .. 0.100  V )   at %7.4r  %M", $abstime );
     $fwrite(outfile,"pe3      VSB    entering OCA ( -3.600  V .. 0.100  V )   at %7.4r  %M\n", $abstime );
     VSB_retc=0;
     $fclose(outfile);
   end

//      VB
   VB = V_B;
   if((VB < -0.1) && (!VB_retc))
   begin
     outfile=$fopen("./occ.err","a");
     $strobe("pe3      VB     leaving  OCA ( < -0.100  V )             at %7.4r  %M", $abstime );
     $fwrite(outfile,"pe3      VB     leaving  OCA ( < -0.100  V )             at %7.4r  %M\n", $abstime );
     VB_retc=1;
     $fclose(outfile);
   end
   if((VB > 3.6) && (!VB_retc))
   begin
     outfile=$fopen("./occ.err","a");
     $strobe("pe3      VB     leaving  OCA ( > 3.600  V )              at %7.4r  %M", $abstime );
     $fwrite(outfile,"pe3      VB     leaving  OCA ( > 3.600  V )              at %7.4r  %M\n", $abstime );
     VB_retc=1;
     $fclose(outfile);
   end
   if((VB > -0.1) && (VB < 3.6) && (VB_retc))
   begin
     outfile=$fopen("./occ.err","a");
     $strobe("pe3      VB     entering OCA ( -0.100  V .. 3.600  V )   at %7.4r  %M", $abstime );
     $fwrite(outfile,"pe3      VB     entering OCA ( -0.100  V .. 3.600  V )   at %7.4r  %M\n", $abstime );
     VB_retc=0;
     $fclose(outfile);
   end

end // analog
endmodule // pe3

// Verilog-A OC Watch for device pe3i Parameters  VGS VGD VDS VDB VSB VB
module pe3i_ahdl(D,G,S,B);
parameter tstep_occ=100n;
inout D,G,S,B;
electrical D,G,S,B;

integer outfile;
real V_B;
real V_S_B;
real V_D_B;
real V_D_S;
real V_G_D;
real V_G_S;
real VGS;
integer VGS_retc;
real VGD;
integer VGD_retc;
real VDS;
integer VDS_retc;
real VDB;
integer VDB_retc;
real VSB;
integer VSB_retc;
real VB;
integer VB_retc;

analog begin

   $bound_step( tstep_occ );
   @(initial_step) begin
      VGS_retc=0;
      VGD_retc=0;
      VDS_retc=0;
      VDB_retc=0;
      VSB_retc=0;
      VB_retc=0;
   end
   V_B = V(B);
   V_S_B = V(S,B);
   V_D_B = V(D,B);
   V_D_S = V(D,S);
   V_G_D = V(G,D);
   V_G_S = V(G,S);

//      VGS
   VGS = V_G_S;
   if((VGS < -3.6) && (!VGS_retc))
   begin
     outfile=$fopen("./occ.err","a");
     $strobe("pe3i     VGS    leaving  OCA ( < -3.600  V )             at %7.4r  %M", $abstime );
     $fwrite(outfile,"pe3i     VGS    leaving  OCA ( < -3.600  V )             at %7.4r  %M\n", $abstime );
     VGS_retc=1;
     $fclose(outfile);
   end
   if((VGS > 3.6) && (!VGS_retc))
   begin
     outfile=$fopen("./occ.err","a");
     $strobe("pe3i     VGS    leaving  OCA ( > 3.600  V )              at %7.4r  %M", $abstime );
     $fwrite(outfile,"pe3i     VGS    leaving  OCA ( > 3.600  V )              at %7.4r  %M\n", $abstime );
     VGS_retc=1;
     $fclose(outfile);
   end
   if((VGS > -3.6) && (VGS < 3.6) && (VGS_retc))
   begin
     outfile=$fopen("./occ.err","a");
     $strobe("pe3i     VGS    entering OCA ( -3.600  V .. 3.600  V )   at %7.4r  %M", $abstime );
     $fwrite(outfile,"pe3i     VGS    entering OCA ( -3.600  V .. 3.600  V )   at %7.4r  %M\n", $abstime );
     VGS_retc=0;
     $fclose(outfile);
   end

//      VGD
   VGD = V_G_D;
   if((VGD < -3.6) && (!VGD_retc))
   begin
     outfile=$fopen("./occ.err","a");
     $strobe("pe3i     VGD    leaving  OCA ( < -3.600  V )             at %7.4r  %M", $abstime );
     $fwrite(outfile,"pe3i     VGD    leaving  OCA ( < -3.600  V )             at %7.4r  %M\n", $abstime );
     VGD_retc=1;
     $fclose(outfile);
   end
   if((VGD > 3.6) && (!VGD_retc))
   begin
     outfile=$fopen("./occ.err","a");
     $strobe("pe3i     VGD    leaving  OCA ( > 3.600  V )              at %7.4r  %M", $abstime );
     $fwrite(outfile,"pe3i     VGD    leaving  OCA ( > 3.600  V )              at %7.4r  %M\n", $abstime );
     VGD_retc=1;
     $fclose(outfile);
   end
   if((VGD > -3.6) && (VGD < 3.6) && (VGD_retc))
   begin
     outfile=$fopen("./occ.err","a");
     $strobe("pe3i     VGD    entering OCA ( -3.600  V .. 3.600  V )   at %7.4r  %M", $abstime );
     $fwrite(outfile,"pe3i     VGD    entering OCA ( -3.600  V .. 3.600  V )   at %7.4r  %M\n", $abstime );
     VGD_retc=0;
     $fclose(outfile);
   end

//      VDS
   VDS = V_D_S;
   if((VDS < -3.6) && (!VDS_retc))
   begin
     outfile=$fopen("./occ.err","a");
     $strobe("pe3i     VDS    leaving  OCA ( < -3.600  V )             at %7.4r  %M", $abstime );
     $fwrite(outfile,"pe3i     VDS    leaving  OCA ( < -3.600  V )             at %7.4r  %M\n", $abstime );
     VDS_retc=1;
     $fclose(outfile);
   end
   if((VDS > 3.6) && (!VDS_retc))
   begin
     outfile=$fopen("./occ.err","a");
     $strobe("pe3i     VDS    leaving  OCA ( > 3.600  V )              at %7.4r  %M", $abstime );
     $fwrite(outfile,"pe3i     VDS    leaving  OCA ( > 3.600  V )              at %7.4r  %M\n", $abstime );
     VDS_retc=1;
     $fclose(outfile);
   end
   if((VDS > -3.6) && (VDS < 3.6) && (VDS_retc))
   begin
     outfile=$fopen("./occ.err","a");
     $strobe("pe3i     VDS    entering OCA ( -3.600  V .. 3.600  V )   at %7.4r  %M", $abstime );
     $fwrite(outfile,"pe3i     VDS    entering OCA ( -3.600  V .. 3.600  V )   at %7.4r  %M\n", $abstime );
     VDS_retc=0;
     $fclose(outfile);
   end

//      VDB
   VDB = V_D_B;
   if((VDB < -3.6) && (!VDB_retc))
   begin
     outfile=$fopen("./occ.err","a");
     $strobe("pe3i     VDB    leaving  OCA ( < -3.600  V )             at %7.4r  %M", $abstime );
     $fwrite(outfile,"pe3i     VDB    leaving  OCA ( < -3.600  V )             at %7.4r  %M\n", $abstime );
     VDB_retc=1;
     $fclose(outfile);
   end
   if((VDB > 0.1) && (!VDB_retc))
   begin
     outfile=$fopen("./occ.err","a");
     $strobe("pe3i     VDB    leaving  OCA ( > 0.100  V )              at %7.4r  %M", $abstime );
     $fwrite(outfile,"pe3i     VDB    leaving  OCA ( > 0.100  V )              at %7.4r  %M\n", $abstime );
     VDB_retc=1;
     $fclose(outfile);
   end
   if((VDB > -3.6) && (VDB < 0.1) && (VDB_retc))
   begin
     outfile=$fopen("./occ.err","a");
     $strobe("pe3i     VDB    entering OCA ( -3.600  V .. 0.100  V )   at %7.4r  %M", $abstime );
     $fwrite(outfile,"pe3i     VDB    entering OCA ( -3.600  V .. 0.100  V )   at %7.4r  %M\n", $abstime );
     VDB_retc=0;
     $fclose(outfile);
   end

//      VSB
   VSB = V_S_B;
   if((VSB < -3.6) && (!VSB_retc))
   begin
     outfile=$fopen("./occ.err","a");
     $strobe("pe3i     VSB    leaving  OCA ( < -3.600  V )             at %7.4r  %M", $abstime );
     $fwrite(outfile,"pe3i     VSB    leaving  OCA ( < -3.600  V )             at %7.4r  %M\n", $abstime );
     VSB_retc=1;
     $fclose(outfile);
   end
   if((VSB > 0.1) && (!VSB_retc))
   begin
     outfile=$fopen("./occ.err","a");
     $strobe("pe3i     VSB    leaving  OCA ( > 0.100  V )              at %7.4r  %M", $abstime );
     $fwrite(outfile,"pe3i     VSB    leaving  OCA ( > 0.100  V )              at %7.4r  %M\n", $abstime );
     VSB_retc=1;
     $fclose(outfile);
   end
   if((VSB > -3.6) && (VSB < 0.1) && (VSB_retc))
   begin
     outfile=$fopen("./occ.err","a");
     $strobe("pe3i     VSB    entering OCA ( -3.600  V .. 0.100  V )   at %7.4r  %M", $abstime );
     $fwrite(outfile,"pe3i     VSB    entering OCA ( -3.600  V .. 0.100  V )   at %7.4r  %M\n", $abstime );
     VSB_retc=0;
     $fclose(outfile);
   end

//      VB
   VB = V_B;
   if((VB < -0.1) && (!VB_retc))
   begin
     outfile=$fopen("./occ.err","a");
     $strobe("pe3i     VB     leaving  OCA ( < -0.100  V )             at %7.4r  %M", $abstime );
     $fwrite(outfile,"pe3i     VB     leaving  OCA ( < -0.100  V )             at %7.4r  %M\n", $abstime );
     VB_retc=1;
     $fclose(outfile);
   end
   if((VB > 3.6) && (!VB_retc))
   begin
     outfile=$fopen("./occ.err","a");
     $strobe("pe3i     VB     leaving  OCA ( > 3.600  V )              at %7.4r  %M", $abstime );
     $fwrite(outfile,"pe3i     VB     leaving  OCA ( > 3.600  V )              at %7.4r  %M\n", $abstime );
     VB_retc=1;
     $fclose(outfile);
   end
   if((VB > -0.1) && (VB < 3.6) && (VB_retc))
   begin
     outfile=$fopen("./occ.err","a");
     $strobe("pe3i     VB     entering OCA ( -0.100  V .. 3.600  V )   at %7.4r  %M", $abstime );
     $fwrite(outfile,"pe3i     VB     entering OCA ( -0.100  V .. 3.600  V )   at %7.4r  %M\n", $abstime );
     VB_retc=0;
     $fclose(outfile);
   end

end // analog
endmodule // pe3i

// Verilog-A OC Watch for device pmma Parameters  VGS VGD VDS VDB VSB VB
module pmma_ahdl(D,G,S,B);
parameter tstep_occ=100n;
inout D,G,S,B;
electrical D,G,S,B;

integer outfile;
real V_B;
real V_S_B;
real V_D_B;
real V_D_S;
real V_G_D;
real V_G_S;
real VGS;
integer VGS_retc;
real VGD;
integer VGD_retc;
real VDS;
integer VDS_retc;
real VDB;
integer VDB_retc;
real VSB;
integer VSB_retc;
real VB;
integer VB_retc;

analog begin

   $bound_step( tstep_occ );
   @(initial_step) begin
      VGS_retc=0;
      VGD_retc=0;
      VDS_retc=0;
      VDB_retc=0;
      VSB_retc=0;
      VB_retc=0;
   end
   V_B = V(B);
   V_S_B = V(S,B);
   V_D_B = V(D,B);
   V_D_S = V(D,S);
   V_G_D = V(G,D);
   V_G_S = V(G,S);

//      VGS
   VGS = V_G_S;
   if((VGS < -15) && (!VGS_retc))
   begin
     outfile=$fopen("./occ.err","a");
     $strobe("pmma     VGS    leaving  OCA ( < -15.000  V )            at %7.4r  %M", $abstime );
     $fwrite(outfile,"pmma     VGS    leaving  OCA ( < -15.000  V )            at %7.4r  %M\n", $abstime );
     VGS_retc=1;
     $fclose(outfile);
   end
   if((VGS > 15) && (!VGS_retc))
   begin
     outfile=$fopen("./occ.err","a");
     $strobe("pmma     VGS    leaving  OCA ( > 15.000  V )             at %7.4r  %M", $abstime );
     $fwrite(outfile,"pmma     VGS    leaving  OCA ( > 15.000  V )             at %7.4r  %M\n", $abstime );
     VGS_retc=1;
     $fclose(outfile);
   end
   if((VGS > -15) && (VGS < 15) && (VGS_retc))
   begin
     outfile=$fopen("./occ.err","a");
     $strobe("pmma     VGS    entering OCA ( -15.000  V .. 15.000  V ) at %7.4r  %M", $abstime );
     $fwrite(outfile,"pmma     VGS    entering OCA ( -15.000  V .. 15.000  V ) at %7.4r  %M\n", $abstime );
     VGS_retc=0;
     $fclose(outfile);
   end

//      VGD
   VGD = V_G_D;
   if((VGD < -15) && (!VGD_retc))
   begin
     outfile=$fopen("./occ.err","a");
     $strobe("pmma     VGD    leaving  OCA ( < -15.000  V )            at %7.4r  %M", $abstime );
     $fwrite(outfile,"pmma     VGD    leaving  OCA ( < -15.000  V )            at %7.4r  %M\n", $abstime );
     VGD_retc=1;
     $fclose(outfile);
   end
   if((VGD > 15) && (!VGD_retc))
   begin
     outfile=$fopen("./occ.err","a");
     $strobe("pmma     VGD    leaving  OCA ( > 15.000  V )             at %7.4r  %M", $abstime );
     $fwrite(outfile,"pmma     VGD    leaving  OCA ( > 15.000  V )             at %7.4r  %M\n", $abstime );
     VGD_retc=1;
     $fclose(outfile);
   end
   if((VGD > -15) && (VGD < 15) && (VGD_retc))
   begin
     outfile=$fopen("./occ.err","a");
     $strobe("pmma     VGD    entering OCA ( -15.000  V .. 15.000  V ) at %7.4r  %M", $abstime );
     $fwrite(outfile,"pmma     VGD    entering OCA ( -15.000  V .. 15.000  V ) at %7.4r  %M\n", $abstime );
     VGD_retc=0;
     $fclose(outfile);
   end

//      VDS
   VDS = V_D_S;
   if((VDS < -15) && (!VDS_retc))
   begin
     outfile=$fopen("./occ.err","a");
     $strobe("pmma     VDS    leaving  OCA ( < -15.000  V )            at %7.4r  %M", $abstime );
     $fwrite(outfile,"pmma     VDS    leaving  OCA ( < -15.000  V )            at %7.4r  %M\n", $abstime );
     VDS_retc=1;
     $fclose(outfile);
   end
   if((VDS > 15) && (!VDS_retc))
   begin
     outfile=$fopen("./occ.err","a");
     $strobe("pmma     VDS    leaving  OCA ( > 15.000  V )             at %7.4r  %M", $abstime );
     $fwrite(outfile,"pmma     VDS    leaving  OCA ( > 15.000  V )             at %7.4r  %M\n", $abstime );
     VDS_retc=1;
     $fclose(outfile);
   end
   if((VDS > -15) && (VDS < 15) && (VDS_retc))
   begin
     outfile=$fopen("./occ.err","a");
     $strobe("pmma     VDS    entering OCA ( -15.000  V .. 15.000  V ) at %7.4r  %M", $abstime );
     $fwrite(outfile,"pmma     VDS    entering OCA ( -15.000  V .. 15.000  V ) at %7.4r  %M\n", $abstime );
     VDS_retc=0;
     $fclose(outfile);
   end

//      VDB
   VDB = V_D_B;
   if((VDB < -15) && (!VDB_retc))
   begin
     outfile=$fopen("./occ.err","a");
     $strobe("pmma     VDB    leaving  OCA ( < -15.000  V )            at %7.4r  %M", $abstime );
     $fwrite(outfile,"pmma     VDB    leaving  OCA ( < -15.000  V )            at %7.4r  %M\n", $abstime );
     VDB_retc=1;
     $fclose(outfile);
   end
   if((VDB > 0.1) && (!VDB_retc))
   begin
     outfile=$fopen("./occ.err","a");
     $strobe("pmma     VDB    leaving  OCA ( > 0.100  V )              at %7.4r  %M", $abstime );
     $fwrite(outfile,"pmma     VDB    leaving  OCA ( > 0.100  V )              at %7.4r  %M\n", $abstime );
     VDB_retc=1;
     $fclose(outfile);
   end
   if((VDB > -15) && (VDB < 0.1) && (VDB_retc))
   begin
     outfile=$fopen("./occ.err","a");
     $strobe("pmma     VDB    entering OCA ( -15.000  V .. 0.100  V )  at %7.4r  %M", $abstime );
     $fwrite(outfile,"pmma     VDB    entering OCA ( -15.000  V .. 0.100  V )  at %7.4r  %M\n", $abstime );
     VDB_retc=0;
     $fclose(outfile);
   end

//      VSB
   VSB = V_S_B;
   if((VSB < -15) && (!VSB_retc))
   begin
     outfile=$fopen("./occ.err","a");
     $strobe("pmma     VSB    leaving  OCA ( < -15.000  V )            at %7.4r  %M", $abstime );
     $fwrite(outfile,"pmma     VSB    leaving  OCA ( < -15.000  V )            at %7.4r  %M\n", $abstime );
     VSB_retc=1;
     $fclose(outfile);
   end
   if((VSB > 0.1) && (!VSB_retc))
   begin
     outfile=$fopen("./occ.err","a");
     $strobe("pmma     VSB    leaving  OCA ( > 0.100  V )              at %7.4r  %M", $abstime );
     $fwrite(outfile,"pmma     VSB    leaving  OCA ( > 0.100  V )              at %7.4r  %M\n", $abstime );
     VSB_retc=1;
     $fclose(outfile);
   end
   if((VSB > -15) && (VSB < 0.1) && (VSB_retc))
   begin
     outfile=$fopen("./occ.err","a");
     $strobe("pmma     VSB    entering OCA ( -15.000  V .. 0.100  V )  at %7.4r  %M", $abstime );
     $fwrite(outfile,"pmma     VSB    entering OCA ( -15.000  V .. 0.100  V )  at %7.4r  %M\n", $abstime );
     VSB_retc=0;
     $fclose(outfile);
   end

//      VB
   VB = V_B;
   if((VB < -0.1) && (!VB_retc))
   begin
     outfile=$fopen("./occ.err","a");
     $strobe("pmma     VB     leaving  OCA ( < -0.100  V )             at %7.4r  %M", $abstime );
     $fwrite(outfile,"pmma     VB     leaving  OCA ( < -0.100  V )             at %7.4r  %M\n", $abstime );
     VB_retc=1;
     $fclose(outfile);
   end
   if((VB > 15) && (!VB_retc))
   begin
     outfile=$fopen("./occ.err","a");
     $strobe("pmma     VB     leaving  OCA ( > 15.000  V )             at %7.4r  %M", $abstime );
     $fwrite(outfile,"pmma     VB     leaving  OCA ( > 15.000  V )             at %7.4r  %M\n", $abstime );
     VB_retc=1;
     $fclose(outfile);
   end
   if((VB > -0.1) && (VB < 15) && (VB_retc))
   begin
     outfile=$fopen("./occ.err","a");
     $strobe("pmma     VB     entering OCA ( -0.100  V .. 15.000  V )  at %7.4r  %M", $abstime );
     $fwrite(outfile,"pmma     VB     entering OCA ( -0.100  V .. 15.000  V )  at %7.4r  %M\n", $abstime );
     VB_retc=0;
     $fclose(outfile);
   end

end // analog
endmodule // pmma

// Verilog-A OC Watch for device ped2 Parameters  VGS VGD VDS VDB VSB VB
module ped2_ahdl(D,G,S,B);
parameter tstep_occ=100n;
inout D,G,S,B;
electrical D,G,S,B;

integer outfile;
real V_B;
real V_S_B;
real V_D_B;
real V_D_S;
real V_G_D;
real V_G_S;
real VGS;
integer VGS_retc;
real VGD;
integer VGD_retc;
real VDS;
integer VDS_retc;
real VDB;
integer VDB_retc;
real VSB;
integer VSB_retc;
real VB;
integer VB_retc;

analog begin

   $bound_step( tstep_occ );
   @(initial_step) begin
      VGS_retc=0;
      VGD_retc=0;
      VDS_retc=0;
      VDB_retc=0;
      VSB_retc=0;
      VB_retc=0;
   end
   V_B = V(B);
   V_S_B = V(S,B);
   V_D_B = V(D,B);
   V_D_S = V(D,S);
   V_G_D = V(G,D);
   V_G_S = V(G,S);

//      VGS
   VGS = V_G_S;
   if((VGS < -18) && (!VGS_retc))
   begin
     outfile=$fopen("./occ.err","a");
     $strobe("ped2     VGS    leaving  OCA ( < -18.000  V )            at %7.4r  %M", $abstime );
     $fwrite(outfile,"ped2     VGS    leaving  OCA ( < -18.000  V )            at %7.4r  %M\n", $abstime );
     VGS_retc=1;
     $fclose(outfile);
   end
   if((VGS > 18) && (!VGS_retc))
   begin
     outfile=$fopen("./occ.err","a");
     $strobe("ped2     VGS    leaving  OCA ( > 18.000  V )             at %7.4r  %M", $abstime );
     $fwrite(outfile,"ped2     VGS    leaving  OCA ( > 18.000  V )             at %7.4r  %M\n", $abstime );
     VGS_retc=1;
     $fclose(outfile);
   end
   if((VGS > -18) && (VGS < 18) && (VGS_retc))
   begin
     outfile=$fopen("./occ.err","a");
     $strobe("ped2     VGS    entering OCA ( -18.000  V .. 18.000  V ) at %7.4r  %M", $abstime );
     $fwrite(outfile,"ped2     VGS    entering OCA ( -18.000  V .. 18.000  V ) at %7.4r  %M\n", $abstime );
     VGS_retc=0;
     $fclose(outfile);
   end

//      VGD
   VGD = V_G_D;
   if((VGD < -18) && (!VGD_retc))
   begin
     outfile=$fopen("./occ.err","a");
     $strobe("ped2     VGD    leaving  OCA ( < -18.000  V )            at %7.4r  %M", $abstime );
     $fwrite(outfile,"ped2     VGD    leaving  OCA ( < -18.000  V )            at %7.4r  %M\n", $abstime );
     VGD_retc=1;
     $fclose(outfile);
   end
   if((VGD > 35) && (!VGD_retc))
   begin
     outfile=$fopen("./occ.err","a");
     $strobe("ped2     VGD    leaving  OCA ( > 35.000  V )             at %7.4r  %M", $abstime );
     $fwrite(outfile,"ped2     VGD    leaving  OCA ( > 35.000  V )             at %7.4r  %M\n", $abstime );
     VGD_retc=1;
     $fclose(outfile);
   end
   if((VGD > -18) && (VGD < 35) && (VGD_retc))
   begin
     outfile=$fopen("./occ.err","a");
     $strobe("ped2     VGD    entering OCA ( -18.000  V .. 35.000  V ) at %7.4r  %M", $abstime );
     $fwrite(outfile,"ped2     VGD    entering OCA ( -18.000  V .. 35.000  V ) at %7.4r  %M\n", $abstime );
     VGD_retc=0;
     $fclose(outfile);
   end

//      VDS
   VDS = V_D_S;
   if((VDS < -35) && (!VDS_retc))
   begin
     outfile=$fopen("./occ.err","a");
     $strobe("ped2     VDS    leaving  OCA ( < -35.000  V )            at %7.4r  %M", $abstime );
     $fwrite(outfile,"ped2     VDS    leaving  OCA ( < -35.000  V )            at %7.4r  %M\n", $abstime );
     VDS_retc=1;
     $fclose(outfile);
   end
   if((VDS > 0.1) && (!VDS_retc))
   begin
     outfile=$fopen("./occ.err","a");
     $strobe("ped2     VDS    leaving  OCA ( > 0.100  V )              at %7.4r  %M", $abstime );
     $fwrite(outfile,"ped2     VDS    leaving  OCA ( > 0.100  V )              at %7.4r  %M\n", $abstime );
     VDS_retc=1;
     $fclose(outfile);
   end
   if((VDS > -35) && (VDS < 0.1) && (VDS_retc))
   begin
     outfile=$fopen("./occ.err","a");
     $strobe("ped2     VDS    entering OCA ( -35.000  V .. 0.100  V )  at %7.4r  %M", $abstime );
     $fwrite(outfile,"ped2     VDS    entering OCA ( -35.000  V .. 0.100  V )  at %7.4r  %M\n", $abstime );
     VDS_retc=0;
     $fclose(outfile);
   end

//      VDB
   VDB = V_D_B;
   if((VDB < -35) && (!VDB_retc))
   begin
     outfile=$fopen("./occ.err","a");
     $strobe("ped2     VDB    leaving  OCA ( < -35.000  V )            at %7.4r  %M", $abstime );
     $fwrite(outfile,"ped2     VDB    leaving  OCA ( < -35.000  V )            at %7.4r  %M\n", $abstime );
     VDB_retc=1;
     $fclose(outfile);
   end
   if((VDB > 0.1) && (!VDB_retc))
   begin
     outfile=$fopen("./occ.err","a");
     $strobe("ped2     VDB    leaving  OCA ( > 0.100  V )              at %7.4r  %M", $abstime );
     $fwrite(outfile,"ped2     VDB    leaving  OCA ( > 0.100  V )              at %7.4r  %M\n", $abstime );
     VDB_retc=1;
     $fclose(outfile);
   end
   if((VDB > -35) && (VDB < 0.1) && (VDB_retc))
   begin
     outfile=$fopen("./occ.err","a");
     $strobe("ped2     VDB    entering OCA ( -35.000  V .. 0.100  V )  at %7.4r  %M", $abstime );
     $fwrite(outfile,"ped2     VDB    entering OCA ( -35.000  V .. 0.100  V )  at %7.4r  %M\n", $abstime );
     VDB_retc=0;
     $fclose(outfile);
   end

//      VSB
   VSB = V_S_B;
   if((VSB < -35) && (!VSB_retc))
   begin
     outfile=$fopen("./occ.err","a");
     $strobe("ped2     VSB    leaving  OCA ( < -35.000  V )            at %7.4r  %M", $abstime );
     $fwrite(outfile,"ped2     VSB    leaving  OCA ( < -35.000  V )            at %7.4r  %M\n", $abstime );
     VSB_retc=1;
     $fclose(outfile);
   end
   if((VSB > 0.1) && (!VSB_retc))
   begin
     outfile=$fopen("./occ.err","a");
     $strobe("ped2     VSB    leaving  OCA ( > 0.100  V )              at %7.4r  %M", $abstime );
     $fwrite(outfile,"ped2     VSB    leaving  OCA ( > 0.100  V )              at %7.4r  %M\n", $abstime );
     VSB_retc=1;
     $fclose(outfile);
   end
   if((VSB > -35) && (VSB < 0.1) && (VSB_retc))
   begin
     outfile=$fopen("./occ.err","a");
     $strobe("ped2     VSB    entering OCA ( -35.000  V .. 0.100  V )  at %7.4r  %M", $abstime );
     $fwrite(outfile,"ped2     VSB    entering OCA ( -35.000  V .. 0.100  V )  at %7.4r  %M\n", $abstime );
     VSB_retc=0;
     $fclose(outfile);
   end

//      VB
   VB = V_B;
   if((VB < -0.1) && (!VB_retc))
   begin
     outfile=$fopen("./occ.err","a");
     $strobe("ped2     VB     leaving  OCA ( < -0.100  V )             at %7.4r  %M", $abstime );
     $fwrite(outfile,"ped2     VB     leaving  OCA ( < -0.100  V )             at %7.4r  %M\n", $abstime );
     VB_retc=1;
     $fclose(outfile);
   end
   if((VB > 35) && (!VB_retc))
   begin
     outfile=$fopen("./occ.err","a");
     $strobe("ped2     VB     leaving  OCA ( > 35.000  V )             at %7.4r  %M", $abstime );
     $fwrite(outfile,"ped2     VB     leaving  OCA ( > 35.000  V )             at %7.4r  %M\n", $abstime );
     VB_retc=1;
     $fclose(outfile);
   end
   if((VB > -0.1) && (VB < 35) && (VB_retc))
   begin
     outfile=$fopen("./occ.err","a");
     $strobe("ped2     VB     entering OCA ( -0.100  V .. 35.000  V )  at %7.4r  %M", $abstime );
     $fwrite(outfile,"ped2     VB     entering OCA ( -0.100  V .. 35.000  V )  at %7.4r  %M\n", $abstime );
     VB_retc=0;
     $fclose(outfile);
   end

end // analog
endmodule // ped2

// Verilog-A OC Watch for device qpva Parameters  VCE VEB VBC
module qpva_ahdl(C,B,E);
parameter tstep_occ=100n;
inout C,B,E;
electrical C,B,E;

integer outfile;
real V_B_C;
real V_E_B;
real V_C_E;
real VCE;
integer VCE_retc;
real VEB;
integer VEB_retc;
real VBC;
integer VBC_retc;

analog begin

   $bound_step( tstep_occ );
   @(initial_step) begin
      VCE_retc=0;
      VEB_retc=0;
      VBC_retc=0;
   end
   V_B_C = V(B,C);
   V_E_B = V(E,B);
   V_C_E = V(C,E);

//      VCE
   VCE = V_C_E;
   if((VCE < -1.98) && (!VCE_retc))
   begin
     outfile=$fopen("./occ.err","a");
     $strobe("qpva     VCE    leaving  OCA ( < -1.980  V )             at %7.4r  %M", $abstime );
     $fwrite(outfile,"qpva     VCE    leaving  OCA ( < -1.980  V )             at %7.4r  %M\n", $abstime );
     VCE_retc=1;
     $fclose(outfile);
   end
   if((VCE > 0.1) && (!VCE_retc))
   begin
     outfile=$fopen("./occ.err","a");
     $strobe("qpva     VCE    leaving  OCA ( > 0.100  V )              at %7.4r  %M", $abstime );
     $fwrite(outfile,"qpva     VCE    leaving  OCA ( > 0.100  V )              at %7.4r  %M\n", $abstime );
     VCE_retc=1;
     $fclose(outfile);
   end
   if((VCE > -1.98) && (VCE < 0.1) && (VCE_retc))
   begin
     outfile=$fopen("./occ.err","a");
     $strobe("qpva     VCE    entering OCA ( -1.980  V .. 0.100  V )   at %7.4r  %M", $abstime );
     $fwrite(outfile,"qpva     VCE    entering OCA ( -1.980  V .. 0.100  V )   at %7.4r  %M\n", $abstime );
     VCE_retc=0;
     $fclose(outfile);
   end

//      VEB
   VEB = V_E_B;
   if((VEB < -1.98) && (!VEB_retc))
   begin
     outfile=$fopen("./occ.err","a");
     $strobe("qpva     VEB    leaving  OCA ( < -1.980  V )             at %7.4r  %M", $abstime );
     $fwrite(outfile,"qpva     VEB    leaving  OCA ( < -1.980  V )             at %7.4r  %M\n", $abstime );
     VEB_retc=1;
     $fclose(outfile);
   end
   if((VEB > 1.5) && (!VEB_retc))
   begin
     outfile=$fopen("./occ.err","a");
     $strobe("qpva     VEB    leaving  OCA ( > 1.500  V )              at %7.4r  %M", $abstime );
     $fwrite(outfile,"qpva     VEB    leaving  OCA ( > 1.500  V )              at %7.4r  %M\n", $abstime );
     VEB_retc=1;
     $fclose(outfile);
   end
   if((VEB > -1.98) && (VEB < 1.5) && (VEB_retc))
   begin
     outfile=$fopen("./occ.err","a");
     $strobe("qpva     VEB    entering OCA ( -1.980  V .. 1.500  V )   at %7.4r  %M", $abstime );
     $fwrite(outfile,"qpva     VEB    entering OCA ( -1.980  V .. 1.500  V )   at %7.4r  %M\n", $abstime );
     VEB_retc=0;
     $fclose(outfile);
   end

//      VBC
   VBC = V_B_C;
   if((VBC < -1.5) && (!VBC_retc))
   begin
     outfile=$fopen("./occ.err","a");
     $strobe("qpva     VBC    leaving  OCA ( < -1.500  V )             at %7.4r  %M", $abstime );
     $fwrite(outfile,"qpva     VBC    leaving  OCA ( < -1.500  V )             at %7.4r  %M\n", $abstime );
     VBC_retc=1;
     $fclose(outfile);
   end
   if((VBC > 1.98) && (!VBC_retc))
   begin
     outfile=$fopen("./occ.err","a");
     $strobe("qpva     VBC    leaving  OCA ( > 1.980  V )              at %7.4r  %M", $abstime );
     $fwrite(outfile,"qpva     VBC    leaving  OCA ( > 1.980  V )              at %7.4r  %M\n", $abstime );
     VBC_retc=1;
     $fclose(outfile);
   end
   if((VBC > -1.5) && (VBC < 1.98) && (VBC_retc))
   begin
     outfile=$fopen("./occ.err","a");
     $strobe("qpva     VBC    entering OCA ( -1.500  V .. 1.980  V )   at %7.4r  %M", $abstime );
     $fwrite(outfile,"qpva     VBC    entering OCA ( -1.500  V .. 1.980  V )   at %7.4r  %M\n", $abstime );
     VBC_retc=0;
     $fclose(outfile);
   end

end // analog
endmodule // qpva

// Verilog-A OC Watch for device qpvb Parameters  VCE VEB VBC
module qpvb_ahdl(C,B,E);
parameter tstep_occ=100n;
inout C,B,E;
electrical C,B,E;

integer outfile;
real V_B_C;
real V_E_B;
real V_C_E;
real VCE;
integer VCE_retc;
real VEB;
integer VEB_retc;
real VBC;
integer VBC_retc;

analog begin

   $bound_step( tstep_occ );
   @(initial_step) begin
      VCE_retc=0;
      VEB_retc=0;
      VBC_retc=0;
   end
   V_B_C = V(B,C);
   V_E_B = V(E,B);
   V_C_E = V(C,E);

//      VCE
   VCE = V_C_E;
   if((VCE < -1.98) && (!VCE_retc))
   begin
     outfile=$fopen("./occ.err","a");
     $strobe("qpvb     VCE    leaving  OCA ( < -1.980  V )             at %7.4r  %M", $abstime );
     $fwrite(outfile,"qpvb     VCE    leaving  OCA ( < -1.980  V )             at %7.4r  %M\n", $abstime );
     VCE_retc=1;
     $fclose(outfile);
   end
   if((VCE > 0.1) && (!VCE_retc))
   begin
     outfile=$fopen("./occ.err","a");
     $strobe("qpvb     VCE    leaving  OCA ( > 0.100  V )              at %7.4r  %M", $abstime );
     $fwrite(outfile,"qpvb     VCE    leaving  OCA ( > 0.100  V )              at %7.4r  %M\n", $abstime );
     VCE_retc=1;
     $fclose(outfile);
   end
   if((VCE > -1.98) && (VCE < 0.1) && (VCE_retc))
   begin
     outfile=$fopen("./occ.err","a");
     $strobe("qpvb     VCE    entering OCA ( -1.980  V .. 0.100  V )   at %7.4r  %M", $abstime );
     $fwrite(outfile,"qpvb     VCE    entering OCA ( -1.980  V .. 0.100  V )   at %7.4r  %M\n", $abstime );
     VCE_retc=0;
     $fclose(outfile);
   end

//      VEB
   VEB = V_E_B;
   if((VEB < -1.98) && (!VEB_retc))
   begin
     outfile=$fopen("./occ.err","a");
     $strobe("qpvb     VEB    leaving  OCA ( < -1.980  V )             at %7.4r  %M", $abstime );
     $fwrite(outfile,"qpvb     VEB    leaving  OCA ( < -1.980  V )             at %7.4r  %M\n", $abstime );
     VEB_retc=1;
     $fclose(outfile);
   end
   if((VEB > 1.5) && (!VEB_retc))
   begin
     outfile=$fopen("./occ.err","a");
     $strobe("qpvb     VEB    leaving  OCA ( > 1.500  V )              at %7.4r  %M", $abstime );
     $fwrite(outfile,"qpvb     VEB    leaving  OCA ( > 1.500  V )              at %7.4r  %M\n", $abstime );
     VEB_retc=1;
     $fclose(outfile);
   end
   if((VEB > -1.98) && (VEB < 1.5) && (VEB_retc))
   begin
     outfile=$fopen("./occ.err","a");
     $strobe("qpvb     VEB    entering OCA ( -1.980  V .. 1.500  V )   at %7.4r  %M", $abstime );
     $fwrite(outfile,"qpvb     VEB    entering OCA ( -1.980  V .. 1.500  V )   at %7.4r  %M\n", $abstime );
     VEB_retc=0;
     $fclose(outfile);
   end

//      VBC
   VBC = V_B_C;
   if((VBC < -1.5) && (!VBC_retc))
   begin
     outfile=$fopen("./occ.err","a");
     $strobe("qpvb     VBC    leaving  OCA ( < -1.500  V )             at %7.4r  %M", $abstime );
     $fwrite(outfile,"qpvb     VBC    leaving  OCA ( < -1.500  V )             at %7.4r  %M\n", $abstime );
     VBC_retc=1;
     $fclose(outfile);
   end
   if((VBC > 1.98) && (!VBC_retc))
   begin
     outfile=$fopen("./occ.err","a");
     $strobe("qpvb     VBC    leaving  OCA ( > 1.980  V )              at %7.4r  %M", $abstime );
     $fwrite(outfile,"qpvb     VBC    leaving  OCA ( > 1.980  V )              at %7.4r  %M\n", $abstime );
     VBC_retc=1;
     $fclose(outfile);
   end
   if((VBC > -1.5) && (VBC < 1.98) && (VBC_retc))
   begin
     outfile=$fopen("./occ.err","a");
     $strobe("qpvb     VBC    entering OCA ( -1.500  V .. 1.980  V )   at %7.4r  %M", $abstime );
     $fwrite(outfile,"qpvb     VBC    entering OCA ( -1.500  V .. 1.980  V )   at %7.4r  %M\n", $abstime );
     VBC_retc=0;
     $fclose(outfile);
   end

end // analog
endmodule // qpvb

// Verilog-A OC Watch for device qpvc Parameters  VCE VEB VBC
module qpvc_ahdl(C,B,E);
parameter tstep_occ=100n;
inout C,B,E;
electrical C,B,E;

integer outfile;
real V_B_C;
real V_E_B;
real V_C_E;
real VCE;
integer VCE_retc;
real VEB;
integer VEB_retc;
real VBC;
integer VBC_retc;

analog begin

   $bound_step( tstep_occ );
   @(initial_step) begin
      VCE_retc=0;
      VEB_retc=0;
      VBC_retc=0;
   end
   V_B_C = V(B,C);
   V_E_B = V(E,B);
   V_C_E = V(C,E);

//      VCE
   VCE = V_C_E;
   if((VCE < -1.98) && (!VCE_retc))
   begin
     outfile=$fopen("./occ.err","a");
     $strobe("qpvc     VCE    leaving  OCA ( < -1.980  V )             at %7.4r  %M", $abstime );
     $fwrite(outfile,"qpvc     VCE    leaving  OCA ( < -1.980  V )             at %7.4r  %M\n", $abstime );
     VCE_retc=1;
     $fclose(outfile);
   end
   if((VCE > 0.1) && (!VCE_retc))
   begin
     outfile=$fopen("./occ.err","a");
     $strobe("qpvc     VCE    leaving  OCA ( > 0.100  V )              at %7.4r  %M", $abstime );
     $fwrite(outfile,"qpvc     VCE    leaving  OCA ( > 0.100  V )              at %7.4r  %M\n", $abstime );
     VCE_retc=1;
     $fclose(outfile);
   end
   if((VCE > -1.98) && (VCE < 0.1) && (VCE_retc))
   begin
     outfile=$fopen("./occ.err","a");
     $strobe("qpvc     VCE    entering OCA ( -1.980  V .. 0.100  V )   at %7.4r  %M", $abstime );
     $fwrite(outfile,"qpvc     VCE    entering OCA ( -1.980  V .. 0.100  V )   at %7.4r  %M\n", $abstime );
     VCE_retc=0;
     $fclose(outfile);
   end

//      VEB
   VEB = V_E_B;
   if((VEB < -1.98) && (!VEB_retc))
   begin
     outfile=$fopen("./occ.err","a");
     $strobe("qpvc     VEB    leaving  OCA ( < -1.980  V )             at %7.4r  %M", $abstime );
     $fwrite(outfile,"qpvc     VEB    leaving  OCA ( < -1.980  V )             at %7.4r  %M\n", $abstime );
     VEB_retc=1;
     $fclose(outfile);
   end
   if((VEB > 1.5) && (!VEB_retc))
   begin
     outfile=$fopen("./occ.err","a");
     $strobe("qpvc     VEB    leaving  OCA ( > 1.500  V )              at %7.4r  %M", $abstime );
     $fwrite(outfile,"qpvc     VEB    leaving  OCA ( > 1.500  V )              at %7.4r  %M\n", $abstime );
     VEB_retc=1;
     $fclose(outfile);
   end
   if((VEB > -1.98) && (VEB < 1.5) && (VEB_retc))
   begin
     outfile=$fopen("./occ.err","a");
     $strobe("qpvc     VEB    entering OCA ( -1.980  V .. 1.500  V )   at %7.4r  %M", $abstime );
     $fwrite(outfile,"qpvc     VEB    entering OCA ( -1.980  V .. 1.500  V )   at %7.4r  %M\n", $abstime );
     VEB_retc=0;
     $fclose(outfile);
   end

//      VBC
   VBC = V_B_C;
   if((VBC < -1.5) && (!VBC_retc))
   begin
     outfile=$fopen("./occ.err","a");
     $strobe("qpvc     VBC    leaving  OCA ( < -1.500  V )             at %7.4r  %M", $abstime );
     $fwrite(outfile,"qpvc     VBC    leaving  OCA ( < -1.500  V )             at %7.4r  %M\n", $abstime );
     VBC_retc=1;
     $fclose(outfile);
   end
   if((VBC > 1.98) && (!VBC_retc))
   begin
     outfile=$fopen("./occ.err","a");
     $strobe("qpvc     VBC    leaving  OCA ( > 1.980  V )              at %7.4r  %M", $abstime );
     $fwrite(outfile,"qpvc     VBC    leaving  OCA ( > 1.980  V )              at %7.4r  %M\n", $abstime );
     VBC_retc=1;
     $fclose(outfile);
   end
   if((VBC > -1.5) && (VBC < 1.98) && (VBC_retc))
   begin
     outfile=$fopen("./occ.err","a");
     $strobe("qpvc     VBC    entering OCA ( -1.500  V .. 1.980  V )   at %7.4r  %M", $abstime );
     $fwrite(outfile,"qpvc     VBC    entering OCA ( -1.500  V .. 1.980  V )   at %7.4r  %M\n", $abstime );
     VBC_retc=0;
     $fclose(outfile);
   end

end // analog
endmodule // qpvc

// Verilog-A OC Watch for device qpva3 Parameters  VCE VEB VBC
module qpva3_ahdl(C,B,E);
parameter tstep_occ=100n;
inout C,B,E;
electrical C,B,E;

integer outfile;
real V_B_C;
real V_E_B;
real V_C_E;
real VCE;
integer VCE_retc;
real VEB;
integer VEB_retc;
real VBC;
integer VBC_retc;

analog begin

   $bound_step( tstep_occ );
   @(initial_step) begin
      VCE_retc=0;
      VEB_retc=0;
      VBC_retc=0;
   end
   V_B_C = V(B,C);
   V_E_B = V(E,B);
   V_C_E = V(C,E);

//      VCE
   VCE = V_C_E;
   if((VCE < -3.6) && (!VCE_retc))
   begin
     outfile=$fopen("./occ.err","a");
     $strobe("qpva3    VCE    leaving  OCA ( < -3.600  V )             at %7.4r  %M", $abstime );
     $fwrite(outfile,"qpva3    VCE    leaving  OCA ( < -3.600  V )             at %7.4r  %M\n", $abstime );
     VCE_retc=1;
     $fclose(outfile);
   end
   if((VCE > 0.1) && (!VCE_retc))
   begin
     outfile=$fopen("./occ.err","a");
     $strobe("qpva3    VCE    leaving  OCA ( > 0.100  V )              at %7.4r  %M", $abstime );
     $fwrite(outfile,"qpva3    VCE    leaving  OCA ( > 0.100  V )              at %7.4r  %M\n", $abstime );
     VCE_retc=1;
     $fclose(outfile);
   end
   if((VCE > -3.6) && (VCE < 0.1) && (VCE_retc))
   begin
     outfile=$fopen("./occ.err","a");
     $strobe("qpva3    VCE    entering OCA ( -3.600  V .. 0.100  V )   at %7.4r  %M", $abstime );
     $fwrite(outfile,"qpva3    VCE    entering OCA ( -3.600  V .. 0.100  V )   at %7.4r  %M\n", $abstime );
     VCE_retc=0;
     $fclose(outfile);
   end

//      VEB
   VEB = V_E_B;
   if((VEB < -3.6) && (!VEB_retc))
   begin
     outfile=$fopen("./occ.err","a");
     $strobe("qpva3    VEB    leaving  OCA ( < -3.600  V )             at %7.4r  %M", $abstime );
     $fwrite(outfile,"qpva3    VEB    leaving  OCA ( < -3.600  V )             at %7.4r  %M\n", $abstime );
     VEB_retc=1;
     $fclose(outfile);
   end
   if((VEB > 1.5) && (!VEB_retc))
   begin
     outfile=$fopen("./occ.err","a");
     $strobe("qpva3    VEB    leaving  OCA ( > 1.500  V )              at %7.4r  %M", $abstime );
     $fwrite(outfile,"qpva3    VEB    leaving  OCA ( > 1.500  V )              at %7.4r  %M\n", $abstime );
     VEB_retc=1;
     $fclose(outfile);
   end
   if((VEB > -3.6) && (VEB < 1.5) && (VEB_retc))
   begin
     outfile=$fopen("./occ.err","a");
     $strobe("qpva3    VEB    entering OCA ( -3.600  V .. 1.500  V )   at %7.4r  %M", $abstime );
     $fwrite(outfile,"qpva3    VEB    entering OCA ( -3.600  V .. 1.500  V )   at %7.4r  %M\n", $abstime );
     VEB_retc=0;
     $fclose(outfile);
   end

//      VBC
   VBC = V_B_C;
   if((VBC < -1.5) && (!VBC_retc))
   begin
     outfile=$fopen("./occ.err","a");
     $strobe("qpva3    VBC    leaving  OCA ( < -1.500  V )             at %7.4r  %M", $abstime );
     $fwrite(outfile,"qpva3    VBC    leaving  OCA ( < -1.500  V )             at %7.4r  %M\n", $abstime );
     VBC_retc=1;
     $fclose(outfile);
   end
   if((VBC > 3.6) && (!VBC_retc))
   begin
     outfile=$fopen("./occ.err","a");
     $strobe("qpva3    VBC    leaving  OCA ( > 3.600  V )              at %7.4r  %M", $abstime );
     $fwrite(outfile,"qpva3    VBC    leaving  OCA ( > 3.600  V )              at %7.4r  %M\n", $abstime );
     VBC_retc=1;
     $fclose(outfile);
   end
   if((VBC > -1.5) && (VBC < 3.6) && (VBC_retc))
   begin
     outfile=$fopen("./occ.err","a");
     $strobe("qpva3    VBC    entering OCA ( -1.500  V .. 3.600  V )   at %7.4r  %M", $abstime );
     $fwrite(outfile,"qpva3    VBC    entering OCA ( -1.500  V .. 3.600  V )   at %7.4r  %M\n", $abstime );
     VBC_retc=0;
     $fclose(outfile);
   end

end // analog
endmodule // qpva3

// Verilog-A OC Watch for device qpvb3 Parameters  VCE VEB VBC
module qpvb3_ahdl(C,B,E);
parameter tstep_occ=100n;
inout C,B,E;
electrical C,B,E;

integer outfile;
real V_B_C;
real V_E_B;
real V_C_E;
real VCE;
integer VCE_retc;
real VEB;
integer VEB_retc;
real VBC;
integer VBC_retc;

analog begin

   $bound_step( tstep_occ );
   @(initial_step) begin
      VCE_retc=0;
      VEB_retc=0;
      VBC_retc=0;
   end
   V_B_C = V(B,C);
   V_E_B = V(E,B);
   V_C_E = V(C,E);

//      VCE
   VCE = V_C_E;
   if((VCE < -3.6) && (!VCE_retc))
   begin
     outfile=$fopen("./occ.err","a");
     $strobe("qpvb3    VCE    leaving  OCA ( < -3.600  V )             at %7.4r  %M", $abstime );
     $fwrite(outfile,"qpvb3    VCE    leaving  OCA ( < -3.600  V )             at %7.4r  %M\n", $abstime );
     VCE_retc=1;
     $fclose(outfile);
   end
   if((VCE > 0.1) && (!VCE_retc))
   begin
     outfile=$fopen("./occ.err","a");
     $strobe("qpvb3    VCE    leaving  OCA ( > 0.100  V )              at %7.4r  %M", $abstime );
     $fwrite(outfile,"qpvb3    VCE    leaving  OCA ( > 0.100  V )              at %7.4r  %M\n", $abstime );
     VCE_retc=1;
     $fclose(outfile);
   end
   if((VCE > -3.6) && (VCE < 0.1) && (VCE_retc))
   begin
     outfile=$fopen("./occ.err","a");
     $strobe("qpvb3    VCE    entering OCA ( -3.600  V .. 0.100  V )   at %7.4r  %M", $abstime );
     $fwrite(outfile,"qpvb3    VCE    entering OCA ( -3.600  V .. 0.100  V )   at %7.4r  %M\n", $abstime );
     VCE_retc=0;
     $fclose(outfile);
   end

//      VEB
   VEB = V_E_B;
   if((VEB < -3.6) && (!VEB_retc))
   begin
     outfile=$fopen("./occ.err","a");
     $strobe("qpvb3    VEB    leaving  OCA ( < -3.600  V )             at %7.4r  %M", $abstime );
     $fwrite(outfile,"qpvb3    VEB    leaving  OCA ( < -3.600  V )             at %7.4r  %M\n", $abstime );
     VEB_retc=1;
     $fclose(outfile);
   end
   if((VEB > 1.5) && (!VEB_retc))
   begin
     outfile=$fopen("./occ.err","a");
     $strobe("qpvb3    VEB    leaving  OCA ( > 1.500  V )              at %7.4r  %M", $abstime );
     $fwrite(outfile,"qpvb3    VEB    leaving  OCA ( > 1.500  V )              at %7.4r  %M\n", $abstime );
     VEB_retc=1;
     $fclose(outfile);
   end
   if((VEB > -3.6) && (VEB < 1.5) && (VEB_retc))
   begin
     outfile=$fopen("./occ.err","a");
     $strobe("qpvb3    VEB    entering OCA ( -3.600  V .. 1.500  V )   at %7.4r  %M", $abstime );
     $fwrite(outfile,"qpvb3    VEB    entering OCA ( -3.600  V .. 1.500  V )   at %7.4r  %M\n", $abstime );
     VEB_retc=0;
     $fclose(outfile);
   end

//      VBC
   VBC = V_B_C;
   if((VBC < -1.5) && (!VBC_retc))
   begin
     outfile=$fopen("./occ.err","a");
     $strobe("qpvb3    VBC    leaving  OCA ( < -1.500  V )             at %7.4r  %M", $abstime );
     $fwrite(outfile,"qpvb3    VBC    leaving  OCA ( < -1.500  V )             at %7.4r  %M\n", $abstime );
     VBC_retc=1;
     $fclose(outfile);
   end
   if((VBC > 3.6) && (!VBC_retc))
   begin
     outfile=$fopen("./occ.err","a");
     $strobe("qpvb3    VBC    leaving  OCA ( > 3.600  V )              at %7.4r  %M", $abstime );
     $fwrite(outfile,"qpvb3    VBC    leaving  OCA ( > 3.600  V )              at %7.4r  %M\n", $abstime );
     VBC_retc=1;
     $fclose(outfile);
   end
   if((VBC > -1.5) && (VBC < 3.6) && (VBC_retc))
   begin
     outfile=$fopen("./occ.err","a");
     $strobe("qpvb3    VBC    entering OCA ( -1.500  V .. 3.600  V )   at %7.4r  %M", $abstime );
     $fwrite(outfile,"qpvb3    VBC    entering OCA ( -1.500  V .. 3.600  V )   at %7.4r  %M\n", $abstime );
     VBC_retc=0;
     $fclose(outfile);
   end

end // analog
endmodule // qpvb3

// Verilog-A OC Watch for device qpvc3 Parameters  VCE VEB VBC
module qpvc3_ahdl(C,B,E);
parameter tstep_occ=100n;
inout C,B,E;
electrical C,B,E;

integer outfile;
real V_B_C;
real V_E_B;
real V_C_E;
real VCE;
integer VCE_retc;
real VEB;
integer VEB_retc;
real VBC;
integer VBC_retc;

analog begin

   $bound_step( tstep_occ );
   @(initial_step) begin
      VCE_retc=0;
      VEB_retc=0;
      VBC_retc=0;
   end
   V_B_C = V(B,C);
   V_E_B = V(E,B);
   V_C_E = V(C,E);

//      VCE
   VCE = V_C_E;
   if((VCE < -3.6) && (!VCE_retc))
   begin
     outfile=$fopen("./occ.err","a");
     $strobe("qpvc3    VCE    leaving  OCA ( < -3.600  V )             at %7.4r  %M", $abstime );
     $fwrite(outfile,"qpvc3    VCE    leaving  OCA ( < -3.600  V )             at %7.4r  %M\n", $abstime );
     VCE_retc=1;
     $fclose(outfile);
   end
   if((VCE > 0.1) && (!VCE_retc))
   begin
     outfile=$fopen("./occ.err","a");
     $strobe("qpvc3    VCE    leaving  OCA ( > 0.100  V )              at %7.4r  %M", $abstime );
     $fwrite(outfile,"qpvc3    VCE    leaving  OCA ( > 0.100  V )              at %7.4r  %M\n", $abstime );
     VCE_retc=1;
     $fclose(outfile);
   end
   if((VCE > -3.6) && (VCE < 0.1) && (VCE_retc))
   begin
     outfile=$fopen("./occ.err","a");
     $strobe("qpvc3    VCE    entering OCA ( -3.600  V .. 0.100  V )   at %7.4r  %M", $abstime );
     $fwrite(outfile,"qpvc3    VCE    entering OCA ( -3.600  V .. 0.100  V )   at %7.4r  %M\n", $abstime );
     VCE_retc=0;
     $fclose(outfile);
   end

//      VEB
   VEB = V_E_B;
   if((VEB < -3.6) && (!VEB_retc))
   begin
     outfile=$fopen("./occ.err","a");
     $strobe("qpvc3    VEB    leaving  OCA ( < -3.600  V )             at %7.4r  %M", $abstime );
     $fwrite(outfile,"qpvc3    VEB    leaving  OCA ( < -3.600  V )             at %7.4r  %M\n", $abstime );
     VEB_retc=1;
     $fclose(outfile);
   end
   if((VEB > 1.5) && (!VEB_retc))
   begin
     outfile=$fopen("./occ.err","a");
     $strobe("qpvc3    VEB    leaving  OCA ( > 1.500  V )              at %7.4r  %M", $abstime );
     $fwrite(outfile,"qpvc3    VEB    leaving  OCA ( > 1.500  V )              at %7.4r  %M\n", $abstime );
     VEB_retc=1;
     $fclose(outfile);
   end
   if((VEB > -3.6) && (VEB < 1.5) && (VEB_retc))
   begin
     outfile=$fopen("./occ.err","a");
     $strobe("qpvc3    VEB    entering OCA ( -3.600  V .. 1.500  V )   at %7.4r  %M", $abstime );
     $fwrite(outfile,"qpvc3    VEB    entering OCA ( -3.600  V .. 1.500  V )   at %7.4r  %M\n", $abstime );
     VEB_retc=0;
     $fclose(outfile);
   end

//      VBC
   VBC = V_B_C;
   if((VBC < -1.5) && (!VBC_retc))
   begin
     outfile=$fopen("./occ.err","a");
     $strobe("qpvc3    VBC    leaving  OCA ( < -1.500  V )             at %7.4r  %M", $abstime );
     $fwrite(outfile,"qpvc3    VBC    leaving  OCA ( < -1.500  V )             at %7.4r  %M\n", $abstime );
     VBC_retc=1;
     $fclose(outfile);
   end
   if((VBC > 3.6) && (!VBC_retc))
   begin
     outfile=$fopen("./occ.err","a");
     $strobe("qpvc3    VBC    leaving  OCA ( > 3.600  V )              at %7.4r  %M", $abstime );
     $fwrite(outfile,"qpvc3    VBC    leaving  OCA ( > 3.600  V )              at %7.4r  %M\n", $abstime );
     VBC_retc=1;
     $fclose(outfile);
   end
   if((VBC > -1.5) && (VBC < 3.6) && (VBC_retc))
   begin
     outfile=$fopen("./occ.err","a");
     $strobe("qpvc3    VBC    entering OCA ( -1.500  V .. 3.600  V )   at %7.4r  %M", $abstime );
     $fwrite(outfile,"qpvc3    VBC    entering OCA ( -1.500  V .. 3.600  V )   at %7.4r  %M\n", $abstime );
     VBC_retc=0;
     $fclose(outfile);
   end

end // analog
endmodule // qpvc3

// Verilog-A OC Watch for device qnva Parameters  VCE VEB VBC VCS
module qnva_ahdl(C,B,E,S);
parameter tstep_occ=100n;
inout C,B,E,S;
electrical C,B,E,S;

integer outfile;
real V_C_S;
real V_B_C;
real V_E_B;
real V_C_E;
real VCE;
integer VCE_retc;
real VEB;
integer VEB_retc;
real VBC;
integer VBC_retc;
real VCS;
integer VCS_retc;

analog begin

   $bound_step( tstep_occ );
   @(initial_step) begin
      VCE_retc=0;
      VEB_retc=0;
      VBC_retc=0;
      VCS_retc=0;
   end
   V_C_S = V(C,S);
   V_B_C = V(B,C);
   V_E_B = V(E,B);
   V_C_E = V(C,E);

//      VCE
   VCE = V_C_E;
   if((VCE < -3.6) && (!VCE_retc))
   begin
     outfile=$fopen("./occ.err","a");
     $strobe("qnva     VCE    leaving  OCA ( < -3.600  V )             at %7.4r  %M", $abstime );
     $fwrite(outfile,"qnva     VCE    leaving  OCA ( < -3.600  V )             at %7.4r  %M\n", $abstime );
     VCE_retc=1;
     $fclose(outfile);
   end
   if((VCE > 3.6) && (!VCE_retc))
   begin
     outfile=$fopen("./occ.err","a");
     $strobe("qnva     VCE    leaving  OCA ( > 3.600  V )              at %7.4r  %M", $abstime );
     $fwrite(outfile,"qnva     VCE    leaving  OCA ( > 3.600  V )              at %7.4r  %M\n", $abstime );
     VCE_retc=1;
     $fclose(outfile);
   end
   if((VCE > -3.6) && (VCE < 3.6) && (VCE_retc))
   begin
     outfile=$fopen("./occ.err","a");
     $strobe("qnva     VCE    entering OCA ( -3.600  V .. 3.600  V )   at %7.4r  %M", $abstime );
     $fwrite(outfile,"qnva     VCE    entering OCA ( -3.600  V .. 3.600  V )   at %7.4r  %M\n", $abstime );
     VCE_retc=0;
     $fclose(outfile);
   end

//      VEB
   VEB = V_E_B;
   if((VEB < -1.5) && (!VEB_retc))
   begin
     outfile=$fopen("./occ.err","a");
     $strobe("qnva     VEB    leaving  OCA ( < -1.500  V )             at %7.4r  %M", $abstime );
     $fwrite(outfile,"qnva     VEB    leaving  OCA ( < -1.500  V )             at %7.4r  %M\n", $abstime );
     VEB_retc=1;
     $fclose(outfile);
   end
   if((VEB > 2.5) && (!VEB_retc))
   begin
     outfile=$fopen("./occ.err","a");
     $strobe("qnva     VEB    leaving  OCA ( > 2.500  V )              at %7.4r  %M", $abstime );
     $fwrite(outfile,"qnva     VEB    leaving  OCA ( > 2.500  V )              at %7.4r  %M\n", $abstime );
     VEB_retc=1;
     $fclose(outfile);
   end
   if((VEB > -1.5) && (VEB < 2.5) && (VEB_retc))
   begin
     outfile=$fopen("./occ.err","a");
     $strobe("qnva     VEB    entering OCA ( -1.500  V .. 2.500  V )   at %7.4r  %M", $abstime );
     $fwrite(outfile,"qnva     VEB    entering OCA ( -1.500  V .. 2.500  V )   at %7.4r  %M\n", $abstime );
     VEB_retc=0;
     $fclose(outfile);
   end

//      VBC
   VBC = V_B_C;
   if((VBC < -3.6) && (!VBC_retc))
   begin
     outfile=$fopen("./occ.err","a");
     $strobe("qnva     VBC    leaving  OCA ( < -3.600  V )             at %7.4r  %M", $abstime );
     $fwrite(outfile,"qnva     VBC    leaving  OCA ( < -3.600  V )             at %7.4r  %M\n", $abstime );
     VBC_retc=1;
     $fclose(outfile);
   end
   if((VBC > 1.5) && (!VBC_retc))
   begin
     outfile=$fopen("./occ.err","a");
     $strobe("qnva     VBC    leaving  OCA ( > 1.500  V )              at %7.4r  %M", $abstime );
     $fwrite(outfile,"qnva     VBC    leaving  OCA ( > 1.500  V )              at %7.4r  %M\n", $abstime );
     VBC_retc=1;
     $fclose(outfile);
   end
   if((VBC > -3.6) && (VBC < 1.5) && (VBC_retc))
   begin
     outfile=$fopen("./occ.err","a");
     $strobe("qnva     VBC    entering OCA ( -3.600  V .. 1.500  V )   at %7.4r  %M", $abstime );
     $fwrite(outfile,"qnva     VBC    entering OCA ( -3.600  V .. 1.500  V )   at %7.4r  %M\n", $abstime );
     VBC_retc=0;
     $fclose(outfile);
   end

//      VCS
   VCS = V_C_S;
   if((VCS < -0.1) && (!VCS_retc))
   begin
     outfile=$fopen("./occ.err","a");
     $strobe("qnva     VCS    leaving  OCA ( < -0.100  V )             at %7.4r  %M", $abstime );
     $fwrite(outfile,"qnva     VCS    leaving  OCA ( < -0.100  V )             at %7.4r  %M\n", $abstime );
     VCS_retc=1;
     $fclose(outfile);
   end
   if((VCS > 15) && (!VCS_retc))
   begin
     outfile=$fopen("./occ.err","a");
     $strobe("qnva     VCS    leaving  OCA ( > 15.000  V )             at %7.4r  %M", $abstime );
     $fwrite(outfile,"qnva     VCS    leaving  OCA ( > 15.000  V )             at %7.4r  %M\n", $abstime );
     VCS_retc=1;
     $fclose(outfile);
   end
   if((VCS > -0.1) && (VCS < 15) && (VCS_retc))
   begin
     outfile=$fopen("./occ.err","a");
     $strobe("qnva     VCS    entering OCA ( -0.100  V .. 15.000  V )  at %7.4r  %M", $abstime );
     $fwrite(outfile,"qnva     VCS    entering OCA ( -0.100  V .. 15.000  V )  at %7.4r  %M\n", $abstime );
     VCS_retc=0;
     $fclose(outfile);
   end

end // analog
endmodule // qnva

// Verilog-A OC Watch for device rdn Parameters  VAS VBS
module rdn_ahdl(A,B,S);
parameter tstep_occ=100n;
inout A,B,S;
electrical A,B,S;

integer outfile;
real V_B_S;
real V_A_S;
real VAS;
integer VAS_retc;
real VBS;
integer VBS_retc;

analog begin

   $bound_step( tstep_occ );
   @(initial_step) begin
      VAS_retc=0;
      VBS_retc=0;
   end
   V_B_S = V(B,S);
   V_A_S = V(A,S);

//      VAS
   VAS = V_A_S;
   if((VAS < -0.1) && (!VAS_retc))
   begin
     outfile=$fopen("./occ.err","a");
     $strobe("rdn      VAS    leaving  OCA ( < -0.100  V )             at %7.4r  %M", $abstime );
     $fwrite(outfile,"rdn      VAS    leaving  OCA ( < -0.100  V )             at %7.4r  %M\n", $abstime );
     VAS_retc=1;
     $fclose(outfile);
   end
   if((VAS > 1.98) && (!VAS_retc))
   begin
     outfile=$fopen("./occ.err","a");
     $strobe("rdn      VAS    leaving  OCA ( > 1.980  V )              at %7.4r  %M", $abstime );
     $fwrite(outfile,"rdn      VAS    leaving  OCA ( > 1.980  V )              at %7.4r  %M\n", $abstime );
     VAS_retc=1;
     $fclose(outfile);
   end
   if((VAS > -0.1) && (VAS < 1.98) && (VAS_retc))
   begin
     outfile=$fopen("./occ.err","a");
     $strobe("rdn      VAS    entering OCA ( -0.100  V .. 1.980  V )   at %7.4r  %M", $abstime );
     $fwrite(outfile,"rdn      VAS    entering OCA ( -0.100  V .. 1.980  V )   at %7.4r  %M\n", $abstime );
     VAS_retc=0;
     $fclose(outfile);
   end

//      VBS
   VBS = V_B_S;
   if((VBS < -0.1) && (!VBS_retc))
   begin
     outfile=$fopen("./occ.err","a");
     $strobe("rdn      VBS    leaving  OCA ( < -0.100  V )             at %7.4r  %M", $abstime );
     $fwrite(outfile,"rdn      VBS    leaving  OCA ( < -0.100  V )             at %7.4r  %M\n", $abstime );
     VBS_retc=1;
     $fclose(outfile);
   end
   if((VBS > 1.98) && (!VBS_retc))
   begin
     outfile=$fopen("./occ.err","a");
     $strobe("rdn      VBS    leaving  OCA ( > 1.980  V )              at %7.4r  %M", $abstime );
     $fwrite(outfile,"rdn      VBS    leaving  OCA ( > 1.980  V )              at %7.4r  %M\n", $abstime );
     VBS_retc=1;
     $fclose(outfile);
   end
   if((VBS > -0.1) && (VBS < 1.98) && (VBS_retc))
   begin
     outfile=$fopen("./occ.err","a");
     $strobe("rdn      VBS    entering OCA ( -0.100  V .. 1.980  V )   at %7.4r  %M", $abstime );
     $fwrite(outfile,"rdn      VBS    entering OCA ( -0.100  V .. 1.980  V )   at %7.4r  %M\n", $abstime );
     VBS_retc=0;
     $fclose(outfile);
   end

end // analog
endmodule // rdn

// Verilog-A OC Watch for device rdn3 Parameters  VAS VBS
module rdn3_ahdl(A,B,S);
parameter tstep_occ=100n;
inout A,B,S;
electrical A,B,S;

integer outfile;
real V_B_S;
real V_A_S;
real VAS;
integer VAS_retc;
real VBS;
integer VBS_retc;

analog begin

   $bound_step( tstep_occ );
   @(initial_step) begin
      VAS_retc=0;
      VBS_retc=0;
   end
   V_B_S = V(B,S);
   V_A_S = V(A,S);

//      VAS
   VAS = V_A_S;
   if((VAS < -0.1) && (!VAS_retc))
   begin
     outfile=$fopen("./occ.err","a");
     $strobe("rdn3     VAS    leaving  OCA ( < -0.100  V )             at %7.4r  %M", $abstime );
     $fwrite(outfile,"rdn3     VAS    leaving  OCA ( < -0.100  V )             at %7.4r  %M\n", $abstime );
     VAS_retc=1;
     $fclose(outfile);
   end
   if((VAS > 3.6) && (!VAS_retc))
   begin
     outfile=$fopen("./occ.err","a");
     $strobe("rdn3     VAS    leaving  OCA ( > 3.600  V )              at %7.4r  %M", $abstime );
     $fwrite(outfile,"rdn3     VAS    leaving  OCA ( > 3.600  V )              at %7.4r  %M\n", $abstime );
     VAS_retc=1;
     $fclose(outfile);
   end
   if((VAS > -0.1) && (VAS < 3.6) && (VAS_retc))
   begin
     outfile=$fopen("./occ.err","a");
     $strobe("rdn3     VAS    entering OCA ( -0.100  V .. 3.600  V )   at %7.4r  %M", $abstime );
     $fwrite(outfile,"rdn3     VAS    entering OCA ( -0.100  V .. 3.600  V )   at %7.4r  %M\n", $abstime );
     VAS_retc=0;
     $fclose(outfile);
   end

//      VBS
   VBS = V_B_S;
   if((VBS < -0.1) && (!VBS_retc))
   begin
     outfile=$fopen("./occ.err","a");
     $strobe("rdn3     VBS    leaving  OCA ( < -0.100  V )             at %7.4r  %M", $abstime );
     $fwrite(outfile,"rdn3     VBS    leaving  OCA ( < -0.100  V )             at %7.4r  %M\n", $abstime );
     VBS_retc=1;
     $fclose(outfile);
   end
   if((VBS > 3.6) && (!VBS_retc))
   begin
     outfile=$fopen("./occ.err","a");
     $strobe("rdn3     VBS    leaving  OCA ( > 3.600  V )              at %7.4r  %M", $abstime );
     $fwrite(outfile,"rdn3     VBS    leaving  OCA ( > 3.600  V )              at %7.4r  %M\n", $abstime );
     VBS_retc=1;
     $fclose(outfile);
   end
   if((VBS > -0.1) && (VBS < 3.6) && (VBS_retc))
   begin
     outfile=$fopen("./occ.err","a");
     $strobe("rdn3     VBS    entering OCA ( -0.100  V .. 3.600  V )   at %7.4r  %M", $abstime );
     $fwrite(outfile,"rdn3     VBS    entering OCA ( -0.100  V .. 3.600  V )   at %7.4r  %M\n", $abstime );
     VBS_retc=0;
     $fclose(outfile);
   end

end // analog
endmodule // rdn3

// Verilog-A OC Watch for device rdp Parameters  VAS VBS
module rdp_ahdl(A,B,S);
parameter tstep_occ=100n;
inout A,B,S;
electrical A,B,S;

integer outfile;
real V_B_S;
real V_A_S;
real VAS;
integer VAS_retc;
real VBS;
integer VBS_retc;

analog begin

   $bound_step( tstep_occ );
   @(initial_step) begin
      VAS_retc=0;
      VBS_retc=0;
   end
   V_B_S = V(B,S);
   V_A_S = V(A,S);

//      VAS
   VAS = V_A_S;
   if((VAS < -1.98) && (!VAS_retc))
   begin
     outfile=$fopen("./occ.err","a");
     $strobe("rdp      VAS    leaving  OCA ( < -1.980  V )             at %7.4r  %M", $abstime );
     $fwrite(outfile,"rdp      VAS    leaving  OCA ( < -1.980  V )             at %7.4r  %M\n", $abstime );
     VAS_retc=1;
     $fclose(outfile);
   end
   if((VAS > 0.1) && (!VAS_retc))
   begin
     outfile=$fopen("./occ.err","a");
     $strobe("rdp      VAS    leaving  OCA ( > 0.100  V )              at %7.4r  %M", $abstime );
     $fwrite(outfile,"rdp      VAS    leaving  OCA ( > 0.100  V )              at %7.4r  %M\n", $abstime );
     VAS_retc=1;
     $fclose(outfile);
   end
   if((VAS > -1.98) && (VAS < 0.1) && (VAS_retc))
   begin
     outfile=$fopen("./occ.err","a");
     $strobe("rdp      VAS    entering OCA ( -1.980  V .. 0.100  V )   at %7.4r  %M", $abstime );
     $fwrite(outfile,"rdp      VAS    entering OCA ( -1.980  V .. 0.100  V )   at %7.4r  %M\n", $abstime );
     VAS_retc=0;
     $fclose(outfile);
   end

//      VBS
   VBS = V_B_S;
   if((VBS < -1.98) && (!VBS_retc))
   begin
     outfile=$fopen("./occ.err","a");
     $strobe("rdp      VBS    leaving  OCA ( < -1.980  V )             at %7.4r  %M", $abstime );
     $fwrite(outfile,"rdp      VBS    leaving  OCA ( < -1.980  V )             at %7.4r  %M\n", $abstime );
     VBS_retc=1;
     $fclose(outfile);
   end
   if((VBS > 0.1) && (!VBS_retc))
   begin
     outfile=$fopen("./occ.err","a");
     $strobe("rdp      VBS    leaving  OCA ( > 0.100  V )              at %7.4r  %M", $abstime );
     $fwrite(outfile,"rdp      VBS    leaving  OCA ( > 0.100  V )              at %7.4r  %M\n", $abstime );
     VBS_retc=1;
     $fclose(outfile);
   end
   if((VBS > -1.98) && (VBS < 0.1) && (VBS_retc))
   begin
     outfile=$fopen("./occ.err","a");
     $strobe("rdp      VBS    entering OCA ( -1.980  V .. 0.100  V )   at %7.4r  %M", $abstime );
     $fwrite(outfile,"rdp      VBS    entering OCA ( -1.980  V .. 0.100  V )   at %7.4r  %M\n", $abstime );
     VBS_retc=0;
     $fclose(outfile);
   end

end // analog
endmodule // rdp

// Verilog-A OC Watch for device rdp_io Parameters  VAS VBS
module rdp_io_ahdl(A,B,S);
parameter tstep_occ=100n;
inout A,B,S;
electrical A,B,S;

integer outfile;
real V_B_S;
real V_A_S;
real VAS;
integer VAS_retc;
real VBS;
integer VBS_retc;

analog begin

   $bound_step( tstep_occ );
   @(initial_step) begin
      VAS_retc=0;
      VBS_retc=0;
   end
   V_B_S = V(B,S);
   V_A_S = V(A,S);

//      VAS
   VAS = V_A_S;
   if((VAS < -1.98) && (!VAS_retc))
   begin
     outfile=$fopen("./occ.err","a");
     $strobe("rdp_io   VAS    leaving  OCA ( < -1.980  V )             at %7.4r  %M", $abstime );
     $fwrite(outfile,"rdp_io   VAS    leaving  OCA ( < -1.980  V )             at %7.4r  %M\n", $abstime );
     VAS_retc=1;
     $fclose(outfile);
   end
   if((VAS > 0.1) && (!VAS_retc))
   begin
     outfile=$fopen("./occ.err","a");
     $strobe("rdp_io   VAS    leaving  OCA ( > 0.100  V )              at %7.4r  %M", $abstime );
     $fwrite(outfile,"rdp_io   VAS    leaving  OCA ( > 0.100  V )              at %7.4r  %M\n", $abstime );
     VAS_retc=1;
     $fclose(outfile);
   end
   if((VAS > -1.98) && (VAS < 0.1) && (VAS_retc))
   begin
     outfile=$fopen("./occ.err","a");
     $strobe("rdp_io   VAS    entering OCA ( -1.980  V .. 0.100  V )   at %7.4r  %M", $abstime );
     $fwrite(outfile,"rdp_io   VAS    entering OCA ( -1.980  V .. 0.100  V )   at %7.4r  %M\n", $abstime );
     VAS_retc=0;
     $fclose(outfile);
   end

//      VBS
   VBS = V_B_S;
   if((VBS < -1.98) && (!VBS_retc))
   begin
     outfile=$fopen("./occ.err","a");
     $strobe("rdp_io   VBS    leaving  OCA ( < -1.980  V )             at %7.4r  %M", $abstime );
     $fwrite(outfile,"rdp_io   VBS    leaving  OCA ( < -1.980  V )             at %7.4r  %M\n", $abstime );
     VBS_retc=1;
     $fclose(outfile);
   end
   if((VBS > 0.1) && (!VBS_retc))
   begin
     outfile=$fopen("./occ.err","a");
     $strobe("rdp_io   VBS    leaving  OCA ( > 0.100  V )              at %7.4r  %M", $abstime );
     $fwrite(outfile,"rdp_io   VBS    leaving  OCA ( > 0.100  V )              at %7.4r  %M\n", $abstime );
     VBS_retc=1;
     $fclose(outfile);
   end
   if((VBS > -1.98) && (VBS < 0.1) && (VBS_retc))
   begin
     outfile=$fopen("./occ.err","a");
     $strobe("rdp_io   VBS    entering OCA ( -1.980  V .. 0.100  V )   at %7.4r  %M", $abstime );
     $fwrite(outfile,"rdp_io   VBS    entering OCA ( -1.980  V .. 0.100  V )   at %7.4r  %M\n", $abstime );
     VBS_retc=0;
     $fclose(outfile);
   end

end // analog
endmodule // rdp_io

// Verilog-A OC Watch for device rdp3 Parameters  VAS VBS
module rdp3_ahdl(A,B,S);
parameter tstep_occ=100n;
inout A,B,S;
electrical A,B,S;

integer outfile;
real V_B_S;
real V_A_S;
real VAS;
integer VAS_retc;
real VBS;
integer VBS_retc;

analog begin

   $bound_step( tstep_occ );
   @(initial_step) begin
      VAS_retc=0;
      VBS_retc=0;
   end
   V_B_S = V(B,S);
   V_A_S = V(A,S);

//      VAS
   VAS = V_A_S;
   if((VAS < -3.6) && (!VAS_retc))
   begin
     outfile=$fopen("./occ.err","a");
     $strobe("rdp3     VAS    leaving  OCA ( < -3.600  V )             at %7.4r  %M", $abstime );
     $fwrite(outfile,"rdp3     VAS    leaving  OCA ( < -3.600  V )             at %7.4r  %M\n", $abstime );
     VAS_retc=1;
     $fclose(outfile);
   end
   if((VAS > 0.1) && (!VAS_retc))
   begin
     outfile=$fopen("./occ.err","a");
     $strobe("rdp3     VAS    leaving  OCA ( > 0.100  V )              at %7.4r  %M", $abstime );
     $fwrite(outfile,"rdp3     VAS    leaving  OCA ( > 0.100  V )              at %7.4r  %M\n", $abstime );
     VAS_retc=1;
     $fclose(outfile);
   end
   if((VAS > -3.6) && (VAS < 0.1) && (VAS_retc))
   begin
     outfile=$fopen("./occ.err","a");
     $strobe("rdp3     VAS    entering OCA ( -3.600  V .. 0.100  V )   at %7.4r  %M", $abstime );
     $fwrite(outfile,"rdp3     VAS    entering OCA ( -3.600  V .. 0.100  V )   at %7.4r  %M\n", $abstime );
     VAS_retc=0;
     $fclose(outfile);
   end

//      VBS
   VBS = V_B_S;
   if((VBS < -3.6) && (!VBS_retc))
   begin
     outfile=$fopen("./occ.err","a");
     $strobe("rdp3     VBS    leaving  OCA ( < -3.600  V )             at %7.4r  %M", $abstime );
     $fwrite(outfile,"rdp3     VBS    leaving  OCA ( < -3.600  V )             at %7.4r  %M\n", $abstime );
     VBS_retc=1;
     $fclose(outfile);
   end
   if((VBS > 0.1) && (!VBS_retc))
   begin
     outfile=$fopen("./occ.err","a");
     $strobe("rdp3     VBS    leaving  OCA ( > 0.100  V )              at %7.4r  %M", $abstime );
     $fwrite(outfile,"rdp3     VBS    leaving  OCA ( > 0.100  V )              at %7.4r  %M\n", $abstime );
     VBS_retc=1;
     $fclose(outfile);
   end
   if((VBS > -3.6) && (VBS < 0.1) && (VBS_retc))
   begin
     outfile=$fopen("./occ.err","a");
     $strobe("rdp3     VBS    entering OCA ( -3.600  V .. 0.100  V )   at %7.4r  %M", $abstime );
     $fwrite(outfile,"rdp3     VBS    entering OCA ( -3.600  V .. 0.100  V )   at %7.4r  %M\n", $abstime );
     VBS_retc=0;
     $fclose(outfile);
   end

end // analog
endmodule // rdp3

// Verilog-A OC Watch for device rnw Parameters  VAS VBS
module rnw_ahdl(A,B,S);
parameter tstep_occ=100n;
inout A,B,S;
electrical A,B,S;

integer outfile;
real V_B_S;
real V_A_S;
real VAS;
integer VAS_retc;
real VBS;
integer VBS_retc;

analog begin

   $bound_step( tstep_occ );
   @(initial_step) begin
      VAS_retc=0;
      VBS_retc=0;
   end
   V_B_S = V(B,S);
   V_A_S = V(A,S);

//      VAS
   VAS = V_A_S;
   if((VAS < -0.1) && (!VAS_retc))
   begin
     outfile=$fopen("./occ.err","a");
     $strobe("rnw      VAS    leaving  OCA ( < -0.100  V )             at %7.4r  %M", $abstime );
     $fwrite(outfile,"rnw      VAS    leaving  OCA ( < -0.100  V )             at %7.4r  %M\n", $abstime );
     VAS_retc=1;
     $fclose(outfile);
   end
   if((VAS > 5.5) && (!VAS_retc))
   begin
     outfile=$fopen("./occ.err","a");
     $strobe("rnw      VAS    leaving  OCA ( > 5.500  V )              at %7.4r  %M", $abstime );
     $fwrite(outfile,"rnw      VAS    leaving  OCA ( > 5.500  V )              at %7.4r  %M\n", $abstime );
     VAS_retc=1;
     $fclose(outfile);
   end
   if((VAS > -0.1) && (VAS < 5.5) && (VAS_retc))
   begin
     outfile=$fopen("./occ.err","a");
     $strobe("rnw      VAS    entering OCA ( -0.100  V .. 5.500  V )   at %7.4r  %M", $abstime );
     $fwrite(outfile,"rnw      VAS    entering OCA ( -0.100  V .. 5.500  V )   at %7.4r  %M\n", $abstime );
     VAS_retc=0;
     $fclose(outfile);
   end

//      VBS
   VBS = V_B_S;
   if((VBS < -0.1) && (!VBS_retc))
   begin
     outfile=$fopen("./occ.err","a");
     $strobe("rnw      VBS    leaving  OCA ( < -0.100  V )             at %7.4r  %M", $abstime );
     $fwrite(outfile,"rnw      VBS    leaving  OCA ( < -0.100  V )             at %7.4r  %M\n", $abstime );
     VBS_retc=1;
     $fclose(outfile);
   end
   if((VBS > 5.5) && (!VBS_retc))
   begin
     outfile=$fopen("./occ.err","a");
     $strobe("rnw      VBS    leaving  OCA ( > 5.500  V )              at %7.4r  %M", $abstime );
     $fwrite(outfile,"rnw      VBS    leaving  OCA ( > 5.500  V )              at %7.4r  %M\n", $abstime );
     VBS_retc=1;
     $fclose(outfile);
   end
   if((VBS > -0.1) && (VBS < 5.5) && (VBS_retc))
   begin
     outfile=$fopen("./occ.err","a");
     $strobe("rnw      VBS    entering OCA ( -0.100  V .. 5.500  V )   at %7.4r  %M", $abstime );
     $fwrite(outfile,"rnw      VBS    entering OCA ( -0.100  V .. 5.500  V )   at %7.4r  %M\n", $abstime );
     VBS_retc=0;
     $fclose(outfile);
   end

end // analog
endmodule // rnw

// Verilog-A OC Watch for device rnw_scr Parameters  VAS VBS
module rnw_scr_ahdl(A,B,S);
parameter tstep_occ=100n;
inout A,B,S;
electrical A,B,S;

integer outfile;
real V_B_S;
real V_A_S;
real VAS;
integer VAS_retc;
real VBS;
integer VBS_retc;

analog begin

   $bound_step( tstep_occ );
   @(initial_step) begin
      VAS_retc=0;
      VBS_retc=0;
   end
   V_B_S = V(B,S);
   V_A_S = V(A,S);

//      VAS
   VAS = V_A_S;
   if((VAS < -0.1) && (!VAS_retc))
   begin
     outfile=$fopen("./occ.err","a");
     $strobe("rnw_scr  VAS    leaving  OCA ( < -0.100  V )             at %7.4r  %M", $abstime );
     $fwrite(outfile,"rnw_scr  VAS    leaving  OCA ( < -0.100  V )             at %7.4r  %M\n", $abstime );
     VAS_retc=1;
     $fclose(outfile);
   end
   if((VAS > 5.5) && (!VAS_retc))
   begin
     outfile=$fopen("./occ.err","a");
     $strobe("rnw_scr  VAS    leaving  OCA ( > 5.500  V )              at %7.4r  %M", $abstime );
     $fwrite(outfile,"rnw_scr  VAS    leaving  OCA ( > 5.500  V )              at %7.4r  %M\n", $abstime );
     VAS_retc=1;
     $fclose(outfile);
   end
   if((VAS > -0.1) && (VAS < 5.5) && (VAS_retc))
   begin
     outfile=$fopen("./occ.err","a");
     $strobe("rnw_scr  VAS    entering OCA ( -0.100  V .. 5.500  V )   at %7.4r  %M", $abstime );
     $fwrite(outfile,"rnw_scr  VAS    entering OCA ( -0.100  V .. 5.500  V )   at %7.4r  %M\n", $abstime );
     VAS_retc=0;
     $fclose(outfile);
   end

//      VBS
   VBS = V_B_S;
   if((VBS < -0.1) && (!VBS_retc))
   begin
     outfile=$fopen("./occ.err","a");
     $strobe("rnw_scr  VBS    leaving  OCA ( < -0.100  V )             at %7.4r  %M", $abstime );
     $fwrite(outfile,"rnw_scr  VBS    leaving  OCA ( < -0.100  V )             at %7.4r  %M\n", $abstime );
     VBS_retc=1;
     $fclose(outfile);
   end
   if((VBS > 5.5) && (!VBS_retc))
   begin
     outfile=$fopen("./occ.err","a");
     $strobe("rnw_scr  VBS    leaving  OCA ( > 5.500  V )              at %7.4r  %M", $abstime );
     $fwrite(outfile,"rnw_scr  VBS    leaving  OCA ( > 5.500  V )              at %7.4r  %M\n", $abstime );
     VBS_retc=1;
     $fclose(outfile);
   end
   if((VBS > -0.1) && (VBS < 5.5) && (VBS_retc))
   begin
     outfile=$fopen("./occ.err","a");
     $strobe("rnw_scr  VBS    entering OCA ( -0.100  V .. 5.500  V )   at %7.4r  %M", $abstime );
     $fwrite(outfile,"rnw_scr  VBS    entering OCA ( -0.100  V .. 5.500  V )   at %7.4r  %M\n", $abstime );
     VBS_retc=0;
     $fclose(outfile);
   end

end // analog
endmodule // rnw_scr

// Verilog-A OC Watch for device rnw3 Parameters  VAS VBS
module rnw3_ahdl(A,B,S);
parameter tstep_occ=100n;
inout A,B,S;
electrical A,B,S;

integer outfile;
real V_B_S;
real V_A_S;
real VAS;
integer VAS_retc;
real VBS;
integer VBS_retc;

analog begin

   $bound_step( tstep_occ );
   @(initial_step) begin
      VAS_retc=0;
      VBS_retc=0;
   end
   V_B_S = V(B,S);
   V_A_S = V(A,S);

//      VAS
   VAS = V_A_S;
   if((VAS < -0.1) && (!VAS_retc))
   begin
     outfile=$fopen("./occ.err","a");
     $strobe("rnw3     VAS    leaving  OCA ( < -0.100  V )             at %7.4r  %M", $abstime );
     $fwrite(outfile,"rnw3     VAS    leaving  OCA ( < -0.100  V )             at %7.4r  %M\n", $abstime );
     VAS_retc=1;
     $fclose(outfile);
   end
   if((VAS > 5.5) && (!VAS_retc))
   begin
     outfile=$fopen("./occ.err","a");
     $strobe("rnw3     VAS    leaving  OCA ( > 5.500  V )              at %7.4r  %M", $abstime );
     $fwrite(outfile,"rnw3     VAS    leaving  OCA ( > 5.500  V )              at %7.4r  %M\n", $abstime );
     VAS_retc=1;
     $fclose(outfile);
   end
   if((VAS > -0.1) && (VAS < 5.5) && (VAS_retc))
   begin
     outfile=$fopen("./occ.err","a");
     $strobe("rnw3     VAS    entering OCA ( -0.100  V .. 5.500  V )   at %7.4r  %M", $abstime );
     $fwrite(outfile,"rnw3     VAS    entering OCA ( -0.100  V .. 5.500  V )   at %7.4r  %M\n", $abstime );
     VAS_retc=0;
     $fclose(outfile);
   end

//      VBS
   VBS = V_B_S;
   if((VBS < -0.1) && (!VBS_retc))
   begin
     outfile=$fopen("./occ.err","a");
     $strobe("rnw3     VBS    leaving  OCA ( < -0.100  V )             at %7.4r  %M", $abstime );
     $fwrite(outfile,"rnw3     VBS    leaving  OCA ( < -0.100  V )             at %7.4r  %M\n", $abstime );
     VBS_retc=1;
     $fclose(outfile);
   end
   if((VBS > 5.5) && (!VBS_retc))
   begin
     outfile=$fopen("./occ.err","a");
     $strobe("rnw3     VBS    leaving  OCA ( > 5.500  V )              at %7.4r  %M", $abstime );
     $fwrite(outfile,"rnw3     VBS    leaving  OCA ( > 5.500  V )              at %7.4r  %M\n", $abstime );
     VBS_retc=1;
     $fclose(outfile);
   end
   if((VBS > -0.1) && (VBS < 5.5) && (VBS_retc))
   begin
     outfile=$fopen("./occ.err","a");
     $strobe("rnw3     VBS    entering OCA ( -0.100  V .. 5.500  V )   at %7.4r  %M", $abstime );
     $fwrite(outfile,"rnw3     VBS    entering OCA ( -0.100  V .. 5.500  V )   at %7.4r  %M\n", $abstime );
     VBS_retc=0;
     $fclose(outfile);
   end

end // analog
endmodule // rnw3

// Verilog-A OC Watch for device rnw3_scr Parameters  VAS VBS
module rnw3_scr_ahdl(A,B,S);
parameter tstep_occ=100n;
inout A,B,S;
electrical A,B,S;

integer outfile;
real V_B_S;
real V_A_S;
real VAS;
integer VAS_retc;
real VBS;
integer VBS_retc;

analog begin

   $bound_step( tstep_occ );
   @(initial_step) begin
      VAS_retc=0;
      VBS_retc=0;
   end
   V_B_S = V(B,S);
   V_A_S = V(A,S);

//      VAS
   VAS = V_A_S;
   if((VAS < -0.1) && (!VAS_retc))
   begin
     outfile=$fopen("./occ.err","a");
     $strobe("rnw3_scr VAS    leaving  OCA ( < -0.100  V )             at %7.4r  %M", $abstime );
     $fwrite(outfile,"rnw3_scr VAS    leaving  OCA ( < -0.100  V )             at %7.4r  %M\n", $abstime );
     VAS_retc=1;
     $fclose(outfile);
   end
   if((VAS > 5.5) && (!VAS_retc))
   begin
     outfile=$fopen("./occ.err","a");
     $strobe("rnw3_scr VAS    leaving  OCA ( > 5.500  V )              at %7.4r  %M", $abstime );
     $fwrite(outfile,"rnw3_scr VAS    leaving  OCA ( > 5.500  V )              at %7.4r  %M\n", $abstime );
     VAS_retc=1;
     $fclose(outfile);
   end
   if((VAS > -0.1) && (VAS < 5.5) && (VAS_retc))
   begin
     outfile=$fopen("./occ.err","a");
     $strobe("rnw3_scr VAS    entering OCA ( -0.100  V .. 5.500  V )   at %7.4r  %M", $abstime );
     $fwrite(outfile,"rnw3_scr VAS    entering OCA ( -0.100  V .. 5.500  V )   at %7.4r  %M\n", $abstime );
     VAS_retc=0;
     $fclose(outfile);
   end

//      VBS
   VBS = V_B_S;
   if((VBS < -0.1) && (!VBS_retc))
   begin
     outfile=$fopen("./occ.err","a");
     $strobe("rnw3_scr VBS    leaving  OCA ( < -0.100  V )             at %7.4r  %M", $abstime );
     $fwrite(outfile,"rnw3_scr VBS    leaving  OCA ( < -0.100  V )             at %7.4r  %M\n", $abstime );
     VBS_retc=1;
     $fclose(outfile);
   end
   if((VBS > 5.5) && (!VBS_retc))
   begin
     outfile=$fopen("./occ.err","a");
     $strobe("rnw3_scr VBS    leaving  OCA ( > 5.500  V )              at %7.4r  %M", $abstime );
     $fwrite(outfile,"rnw3_scr VBS    leaving  OCA ( > 5.500  V )              at %7.4r  %M\n", $abstime );
     VBS_retc=1;
     $fclose(outfile);
   end
   if((VBS > -0.1) && (VBS < 5.5) && (VBS_retc))
   begin
     outfile=$fopen("./occ.err","a");
     $strobe("rnw3_scr VBS    entering OCA ( -0.100  V .. 5.500  V )   at %7.4r  %M", $abstime );
     $fwrite(outfile,"rnw3_scr VBS    entering OCA ( -0.100  V .. 5.500  V )   at %7.4r  %M\n", $abstime );
     VBS_retc=0;
     $fclose(outfile);
   end

end // analog
endmodule // rnw3_scr

// Verilog-A OC Watch for device rdnwmv Parameters  VAS VBS
module rdnwmv_ahdl(A,B,S);
parameter tstep_occ=100n;
inout A,B,S;
electrical A,B,S;

integer outfile;
real V_B_S;
real V_A_S;
real VAS;
integer VAS_retc;
real VBS;
integer VBS_retc;

analog begin

   $bound_step( tstep_occ );
   @(initial_step) begin
      VAS_retc=0;
      VBS_retc=0;
   end
   V_B_S = V(B,S);
   V_A_S = V(A,S);

//      VAS
   VAS = V_A_S;
   if((VAS < -0.1) && (!VAS_retc))
   begin
     outfile=$fopen("./occ.err","a");
     $strobe("rdnwmv   VAS    leaving  OCA ( < -0.100  V )             at %7.4r  %M", $abstime );
     $fwrite(outfile,"rdnwmv   VAS    leaving  OCA ( < -0.100  V )             at %7.4r  %M\n", $abstime );
     VAS_retc=1;
     $fclose(outfile);
   end
   if((VAS > 5.5) && (!VAS_retc))
   begin
     outfile=$fopen("./occ.err","a");
     $strobe("rdnwmv   VAS    leaving  OCA ( > 5.500  V )              at %7.4r  %M", $abstime );
     $fwrite(outfile,"rdnwmv   VAS    leaving  OCA ( > 5.500  V )              at %7.4r  %M\n", $abstime );
     VAS_retc=1;
     $fclose(outfile);
   end
   if((VAS > -0.1) && (VAS < 5.5) && (VAS_retc))
   begin
     outfile=$fopen("./occ.err","a");
     $strobe("rdnwmv   VAS    entering OCA ( -0.100  V .. 5.500  V )   at %7.4r  %M", $abstime );
     $fwrite(outfile,"rdnwmv   VAS    entering OCA ( -0.100  V .. 5.500  V )   at %7.4r  %M\n", $abstime );
     VAS_retc=0;
     $fclose(outfile);
   end

//      VBS
   VBS = V_B_S;
   if((VBS < -0.1) && (!VBS_retc))
   begin
     outfile=$fopen("./occ.err","a");
     $strobe("rdnwmv   VBS    leaving  OCA ( < -0.100  V )             at %7.4r  %M", $abstime );
     $fwrite(outfile,"rdnwmv   VBS    leaving  OCA ( < -0.100  V )             at %7.4r  %M\n", $abstime );
     VBS_retc=1;
     $fclose(outfile);
   end
   if((VBS > 5.5) && (!VBS_retc))
   begin
     outfile=$fopen("./occ.err","a");
     $strobe("rdnwmv   VBS    leaving  OCA ( > 5.500  V )              at %7.4r  %M", $abstime );
     $fwrite(outfile,"rdnwmv   VBS    leaving  OCA ( > 5.500  V )              at %7.4r  %M\n", $abstime );
     VBS_retc=1;
     $fclose(outfile);
   end
   if((VBS > -0.1) && (VBS < 5.5) && (VBS_retc))
   begin
     outfile=$fopen("./occ.err","a");
     $strobe("rdnwmv   VBS    entering OCA ( -0.100  V .. 5.500  V )   at %7.4r  %M", $abstime );
     $fwrite(outfile,"rdnwmv   VBS    entering OCA ( -0.100  V .. 5.500  V )   at %7.4r  %M\n", $abstime );
     VBS_retc=0;
     $fclose(outfile);
   end

end // analog
endmodule // rdnwmv

// Verilog-A OC Watch for device rm1 Parameters  VA VB
module rm1_ahdl(A,B);
parameter tstep_occ=100n;
inout A,B;
electrical A,B;

integer outfile;
real V_B;
real V_A;
real VA;
integer VA_retc;
real VB;
integer VB_retc;

analog begin

   $bound_step( tstep_occ );
   @(initial_step) begin
      VA_retc=0;
      VB_retc=0;
   end
   V_B = V(B);
   V_A = V(A);

//      VA
   VA = V_A;
   if((VA < -40) && (!VA_retc))
   begin
     outfile=$fopen("./occ.err","a");
     $strobe("rm1      VA     leaving  OCA ( < -40.000  V )            at %7.4r  %M", $abstime );
     $fwrite(outfile,"rm1      VA     leaving  OCA ( < -40.000  V )            at %7.4r  %M\n", $abstime );
     VA_retc=1;
     $fclose(outfile);
   end
   if((VA > 40) && (!VA_retc))
   begin
     outfile=$fopen("./occ.err","a");
     $strobe("rm1      VA     leaving  OCA ( > 40.000  V )             at %7.4r  %M", $abstime );
     $fwrite(outfile,"rm1      VA     leaving  OCA ( > 40.000  V )             at %7.4r  %M\n", $abstime );
     VA_retc=1;
     $fclose(outfile);
   end
   if((VA > -40) && (VA < 40) && (VA_retc))
   begin
     outfile=$fopen("./occ.err","a");
     $strobe("rm1      VA     entering OCA ( -40.000  V .. 40.000  V ) at %7.4r  %M", $abstime );
     $fwrite(outfile,"rm1      VA     entering OCA ( -40.000  V .. 40.000  V ) at %7.4r  %M\n", $abstime );
     VA_retc=0;
     $fclose(outfile);
   end

//      VB
   VB = V_B;
   if((VB < -40) && (!VB_retc))
   begin
     outfile=$fopen("./occ.err","a");
     $strobe("rm1      VB     leaving  OCA ( < -40.000  V )            at %7.4r  %M", $abstime );
     $fwrite(outfile,"rm1      VB     leaving  OCA ( < -40.000  V )            at %7.4r  %M\n", $abstime );
     VB_retc=1;
     $fclose(outfile);
   end
   if((VB > 40) && (!VB_retc))
   begin
     outfile=$fopen("./occ.err","a");
     $strobe("rm1      VB     leaving  OCA ( > 40.000  V )             at %7.4r  %M", $abstime );
     $fwrite(outfile,"rm1      VB     leaving  OCA ( > 40.000  V )             at %7.4r  %M\n", $abstime );
     VB_retc=1;
     $fclose(outfile);
   end
   if((VB > -40) && (VB < 40) && (VB_retc))
   begin
     outfile=$fopen("./occ.err","a");
     $strobe("rm1      VB     entering OCA ( -40.000  V .. 40.000  V ) at %7.4r  %M", $abstime );
     $fwrite(outfile,"rm1      VB     entering OCA ( -40.000  V .. 40.000  V ) at %7.4r  %M\n", $abstime );
     VB_retc=0;
     $fclose(outfile);
   end

end // analog
endmodule // rm1

// Verilog-A OC Watch for device rm2 Parameters  VA VB
module rm2_ahdl(A,B);
parameter tstep_occ=100n;
inout A,B;
electrical A,B;

integer outfile;
real V_B;
real V_A;
real VA;
integer VA_retc;
real VB;
integer VB_retc;

analog begin

   $bound_step( tstep_occ );
   @(initial_step) begin
      VA_retc=0;
      VB_retc=0;
   end
   V_B = V(B);
   V_A = V(A);

//      VA
   VA = V_A;
   if((VA < -40) && (!VA_retc))
   begin
     outfile=$fopen("./occ.err","a");
     $strobe("rm2      VA     leaving  OCA ( < -40.000  V )            at %7.4r  %M", $abstime );
     $fwrite(outfile,"rm2      VA     leaving  OCA ( < -40.000  V )            at %7.4r  %M\n", $abstime );
     VA_retc=1;
     $fclose(outfile);
   end
   if((VA > 40) && (!VA_retc))
   begin
     outfile=$fopen("./occ.err","a");
     $strobe("rm2      VA     leaving  OCA ( > 40.000  V )             at %7.4r  %M", $abstime );
     $fwrite(outfile,"rm2      VA     leaving  OCA ( > 40.000  V )             at %7.4r  %M\n", $abstime );
     VA_retc=1;
     $fclose(outfile);
   end
   if((VA > -40) && (VA < 40) && (VA_retc))
   begin
     outfile=$fopen("./occ.err","a");
     $strobe("rm2      VA     entering OCA ( -40.000  V .. 40.000  V ) at %7.4r  %M", $abstime );
     $fwrite(outfile,"rm2      VA     entering OCA ( -40.000  V .. 40.000  V ) at %7.4r  %M\n", $abstime );
     VA_retc=0;
     $fclose(outfile);
   end

//      VB
   VB = V_B;
   if((VB < -40) && (!VB_retc))
   begin
     outfile=$fopen("./occ.err","a");
     $strobe("rm2      VB     leaving  OCA ( < -40.000  V )            at %7.4r  %M", $abstime );
     $fwrite(outfile,"rm2      VB     leaving  OCA ( < -40.000  V )            at %7.4r  %M\n", $abstime );
     VB_retc=1;
     $fclose(outfile);
   end
   if((VB > 40) && (!VB_retc))
   begin
     outfile=$fopen("./occ.err","a");
     $strobe("rm2      VB     leaving  OCA ( > 40.000  V )             at %7.4r  %M", $abstime );
     $fwrite(outfile,"rm2      VB     leaving  OCA ( > 40.000  V )             at %7.4r  %M\n", $abstime );
     VB_retc=1;
     $fclose(outfile);
   end
   if((VB > -40) && (VB < 40) && (VB_retc))
   begin
     outfile=$fopen("./occ.err","a");
     $strobe("rm2      VB     entering OCA ( -40.000  V .. 40.000  V ) at %7.4r  %M", $abstime );
     $fwrite(outfile,"rm2      VB     entering OCA ( -40.000  V .. 40.000  V ) at %7.4r  %M\n", $abstime );
     VB_retc=0;
     $fclose(outfile);
   end

end // analog
endmodule // rm2

// Verilog-A OC Watch for device rm3 Parameters  VA VB
module rm3_ahdl(A,B);
parameter tstep_occ=100n;
inout A,B;
electrical A,B;

integer outfile;
real V_B;
real V_A;
real VA;
integer VA_retc;
real VB;
integer VB_retc;

analog begin

   $bound_step( tstep_occ );
   @(initial_step) begin
      VA_retc=0;
      VB_retc=0;
   end
   V_B = V(B);
   V_A = V(A);

//      VA
   VA = V_A;
   if((VA < -40) && (!VA_retc))
   begin
     outfile=$fopen("./occ.err","a");
     $strobe("rm3      VA     leaving  OCA ( < -40.000  V )            at %7.4r  %M", $abstime );
     $fwrite(outfile,"rm3      VA     leaving  OCA ( < -40.000  V )            at %7.4r  %M\n", $abstime );
     VA_retc=1;
     $fclose(outfile);
   end
   if((VA > 40) && (!VA_retc))
   begin
     outfile=$fopen("./occ.err","a");
     $strobe("rm3      VA     leaving  OCA ( > 40.000  V )             at %7.4r  %M", $abstime );
     $fwrite(outfile,"rm3      VA     leaving  OCA ( > 40.000  V )             at %7.4r  %M\n", $abstime );
     VA_retc=1;
     $fclose(outfile);
   end
   if((VA > -40) && (VA < 40) && (VA_retc))
   begin
     outfile=$fopen("./occ.err","a");
     $strobe("rm3      VA     entering OCA ( -40.000  V .. 40.000  V ) at %7.4r  %M", $abstime );
     $fwrite(outfile,"rm3      VA     entering OCA ( -40.000  V .. 40.000  V ) at %7.4r  %M\n", $abstime );
     VA_retc=0;
     $fclose(outfile);
   end

//      VB
   VB = V_B;
   if((VB < -40) && (!VB_retc))
   begin
     outfile=$fopen("./occ.err","a");
     $strobe("rm3      VB     leaving  OCA ( < -40.000  V )            at %7.4r  %M", $abstime );
     $fwrite(outfile,"rm3      VB     leaving  OCA ( < -40.000  V )            at %7.4r  %M\n", $abstime );
     VB_retc=1;
     $fclose(outfile);
   end
   if((VB > 40) && (!VB_retc))
   begin
     outfile=$fopen("./occ.err","a");
     $strobe("rm3      VB     leaving  OCA ( > 40.000  V )             at %7.4r  %M", $abstime );
     $fwrite(outfile,"rm3      VB     leaving  OCA ( > 40.000  V )             at %7.4r  %M\n", $abstime );
     VB_retc=1;
     $fclose(outfile);
   end
   if((VB > -40) && (VB < 40) && (VB_retc))
   begin
     outfile=$fopen("./occ.err","a");
     $strobe("rm3      VB     entering OCA ( -40.000  V .. 40.000  V ) at %7.4r  %M", $abstime );
     $fwrite(outfile,"rm3      VB     entering OCA ( -40.000  V .. 40.000  V ) at %7.4r  %M\n", $abstime );
     VB_retc=0;
     $fclose(outfile);
   end

end // analog
endmodule // rm3

// Verilog-A OC Watch for device rm4 Parameters  VA VB
module rm4_ahdl(A,B);
parameter tstep_occ=100n;
inout A,B;
electrical A,B;

integer outfile;
real V_B;
real V_A;
real VA;
integer VA_retc;
real VB;
integer VB_retc;

analog begin

   $bound_step( tstep_occ );
   @(initial_step) begin
      VA_retc=0;
      VB_retc=0;
   end
   V_B = V(B);
   V_A = V(A);

//      VA
   VA = V_A;
   if((VA < -40) && (!VA_retc))
   begin
     outfile=$fopen("./occ.err","a");
     $strobe("rm4      VA     leaving  OCA ( < -40.000  V )            at %7.4r  %M", $abstime );
     $fwrite(outfile,"rm4      VA     leaving  OCA ( < -40.000  V )            at %7.4r  %M\n", $abstime );
     VA_retc=1;
     $fclose(outfile);
   end
   if((VA > 40) && (!VA_retc))
   begin
     outfile=$fopen("./occ.err","a");
     $strobe("rm4      VA     leaving  OCA ( > 40.000  V )             at %7.4r  %M", $abstime );
     $fwrite(outfile,"rm4      VA     leaving  OCA ( > 40.000  V )             at %7.4r  %M\n", $abstime );
     VA_retc=1;
     $fclose(outfile);
   end
   if((VA > -40) && (VA < 40) && (VA_retc))
   begin
     outfile=$fopen("./occ.err","a");
     $strobe("rm4      VA     entering OCA ( -40.000  V .. 40.000  V ) at %7.4r  %M", $abstime );
     $fwrite(outfile,"rm4      VA     entering OCA ( -40.000  V .. 40.000  V ) at %7.4r  %M\n", $abstime );
     VA_retc=0;
     $fclose(outfile);
   end

//      VB
   VB = V_B;
   if((VB < -40) && (!VB_retc))
   begin
     outfile=$fopen("./occ.err","a");
     $strobe("rm4      VB     leaving  OCA ( < -40.000  V )            at %7.4r  %M", $abstime );
     $fwrite(outfile,"rm4      VB     leaving  OCA ( < -40.000  V )            at %7.4r  %M\n", $abstime );
     VB_retc=1;
     $fclose(outfile);
   end
   if((VB > 40) && (!VB_retc))
   begin
     outfile=$fopen("./occ.err","a");
     $strobe("rm4      VB     leaving  OCA ( > 40.000  V )             at %7.4r  %M", $abstime );
     $fwrite(outfile,"rm4      VB     leaving  OCA ( > 40.000  V )             at %7.4r  %M\n", $abstime );
     VB_retc=1;
     $fclose(outfile);
   end
   if((VB > -40) && (VB < 40) && (VB_retc))
   begin
     outfile=$fopen("./occ.err","a");
     $strobe("rm4      VB     entering OCA ( -40.000  V .. 40.000  V ) at %7.4r  %M", $abstime );
     $fwrite(outfile,"rm4      VB     entering OCA ( -40.000  V .. 40.000  V ) at %7.4r  %M\n", $abstime );
     VB_retc=0;
     $fclose(outfile);
   end

end // analog
endmodule // rm4

// Verilog-A OC Watch for device rm5 Parameters  VA VB
module rm5_ahdl(A,B);
parameter tstep_occ=100n;
inout A,B;
electrical A,B;

integer outfile;
real V_B;
real V_A;
real VA;
integer VA_retc;
real VB;
integer VB_retc;

analog begin

   $bound_step( tstep_occ );
   @(initial_step) begin
      VA_retc=0;
      VB_retc=0;
   end
   V_B = V(B);
   V_A = V(A);

//      VA
   VA = V_A;
   if((VA < -40) && (!VA_retc))
   begin
     outfile=$fopen("./occ.err","a");
     $strobe("rm5      VA     leaving  OCA ( < -40.000  V )            at %7.4r  %M", $abstime );
     $fwrite(outfile,"rm5      VA     leaving  OCA ( < -40.000  V )            at %7.4r  %M\n", $abstime );
     VA_retc=1;
     $fclose(outfile);
   end
   if((VA > 40) && (!VA_retc))
   begin
     outfile=$fopen("./occ.err","a");
     $strobe("rm5      VA     leaving  OCA ( > 40.000  V )             at %7.4r  %M", $abstime );
     $fwrite(outfile,"rm5      VA     leaving  OCA ( > 40.000  V )             at %7.4r  %M\n", $abstime );
     VA_retc=1;
     $fclose(outfile);
   end
   if((VA > -40) && (VA < 40) && (VA_retc))
   begin
     outfile=$fopen("./occ.err","a");
     $strobe("rm5      VA     entering OCA ( -40.000  V .. 40.000  V ) at %7.4r  %M", $abstime );
     $fwrite(outfile,"rm5      VA     entering OCA ( -40.000  V .. 40.000  V ) at %7.4r  %M\n", $abstime );
     VA_retc=0;
     $fclose(outfile);
   end

//      VB
   VB = V_B;
   if((VB < -40) && (!VB_retc))
   begin
     outfile=$fopen("./occ.err","a");
     $strobe("rm5      VB     leaving  OCA ( < -40.000  V )            at %7.4r  %M", $abstime );
     $fwrite(outfile,"rm5      VB     leaving  OCA ( < -40.000  V )            at %7.4r  %M\n", $abstime );
     VB_retc=1;
     $fclose(outfile);
   end
   if((VB > 40) && (!VB_retc))
   begin
     outfile=$fopen("./occ.err","a");
     $strobe("rm5      VB     leaving  OCA ( > 40.000  V )             at %7.4r  %M", $abstime );
     $fwrite(outfile,"rm5      VB     leaving  OCA ( > 40.000  V )             at %7.4r  %M\n", $abstime );
     VB_retc=1;
     $fclose(outfile);
   end
   if((VB > -40) && (VB < 40) && (VB_retc))
   begin
     outfile=$fopen("./occ.err","a");
     $strobe("rm5      VB     entering OCA ( -40.000  V .. 40.000  V ) at %7.4r  %M", $abstime );
     $fwrite(outfile,"rm5      VB     entering OCA ( -40.000  V .. 40.000  V ) at %7.4r  %M\n", $abstime );
     VB_retc=0;
     $fclose(outfile);
   end

end // analog
endmodule // rm5

// Verilog-A OC Watch for device rmtp Parameters  VA VB
module rmtp_ahdl(A,B);
parameter tstep_occ=100n;
inout A,B;
electrical A,B;

integer outfile;
real V_B;
real V_A;
real VA;
integer VA_retc;
real VB;
integer VB_retc;

analog begin

   $bound_step( tstep_occ );
   @(initial_step) begin
      VA_retc=0;
      VB_retc=0;
   end
   V_B = V(B);
   V_A = V(A);

//      VA
   VA = V_A;
   if((VA < -40) && (!VA_retc))
   begin
     outfile=$fopen("./occ.err","a");
     $strobe("rmtp     VA     leaving  OCA ( < -40.000  V )            at %7.4r  %M", $abstime );
     $fwrite(outfile,"rmtp     VA     leaving  OCA ( < -40.000  V )            at %7.4r  %M\n", $abstime );
     VA_retc=1;
     $fclose(outfile);
   end
   if((VA > 40) && (!VA_retc))
   begin
     outfile=$fopen("./occ.err","a");
     $strobe("rmtp     VA     leaving  OCA ( > 40.000  V )             at %7.4r  %M", $abstime );
     $fwrite(outfile,"rmtp     VA     leaving  OCA ( > 40.000  V )             at %7.4r  %M\n", $abstime );
     VA_retc=1;
     $fclose(outfile);
   end
   if((VA > -40) && (VA < 40) && (VA_retc))
   begin
     outfile=$fopen("./occ.err","a");
     $strobe("rmtp     VA     entering OCA ( -40.000  V .. 40.000  V ) at %7.4r  %M", $abstime );
     $fwrite(outfile,"rmtp     VA     entering OCA ( -40.000  V .. 40.000  V ) at %7.4r  %M\n", $abstime );
     VA_retc=0;
     $fclose(outfile);
   end

//      VB
   VB = V_B;
   if((VB < -40) && (!VB_retc))
   begin
     outfile=$fopen("./occ.err","a");
     $strobe("rmtp     VB     leaving  OCA ( < -40.000  V )            at %7.4r  %M", $abstime );
     $fwrite(outfile,"rmtp     VB     leaving  OCA ( < -40.000  V )            at %7.4r  %M\n", $abstime );
     VB_retc=1;
     $fclose(outfile);
   end
   if((VB > 40) && (!VB_retc))
   begin
     outfile=$fopen("./occ.err","a");
     $strobe("rmtp     VB     leaving  OCA ( > 40.000  V )             at %7.4r  %M", $abstime );
     $fwrite(outfile,"rmtp     VB     leaving  OCA ( > 40.000  V )             at %7.4r  %M\n", $abstime );
     VB_retc=1;
     $fclose(outfile);
   end
   if((VB > -40) && (VB < 40) && (VB_retc))
   begin
     outfile=$fopen("./occ.err","a");
     $strobe("rmtp     VB     entering OCA ( -40.000  V .. 40.000  V ) at %7.4r  %M", $abstime );
     $fwrite(outfile,"rmtp     VB     entering OCA ( -40.000  V .. 40.000  V ) at %7.4r  %M\n", $abstime );
     VB_retc=0;
     $fclose(outfile);
   end

end // analog
endmodule // rmtp

// Verilog-A OC Watch for device rmtpl Parameters  VA VB
module rmtpl_ahdl(A,B);
parameter tstep_occ=100n;
inout A,B;
electrical A,B;

integer outfile;
real V_B;
real V_A;
real VA;
integer VA_retc;
real VB;
integer VB_retc;

analog begin

   $bound_step( tstep_occ );
   @(initial_step) begin
      VA_retc=0;
      VB_retc=0;
   end
   V_B = V(B);
   V_A = V(A);

//      VA
   VA = V_A;
   if((VA < -40) && (!VA_retc))
   begin
     outfile=$fopen("./occ.err","a");
     $strobe("rmtpl    VA     leaving  OCA ( < -40.000  V )            at %7.4r  %M", $abstime );
     $fwrite(outfile,"rmtpl    VA     leaving  OCA ( < -40.000  V )            at %7.4r  %M\n", $abstime );
     VA_retc=1;
     $fclose(outfile);
   end
   if((VA > 40) && (!VA_retc))
   begin
     outfile=$fopen("./occ.err","a");
     $strobe("rmtpl    VA     leaving  OCA ( > 40.000  V )             at %7.4r  %M", $abstime );
     $fwrite(outfile,"rmtpl    VA     leaving  OCA ( > 40.000  V )             at %7.4r  %M\n", $abstime );
     VA_retc=1;
     $fclose(outfile);
   end
   if((VA > -40) && (VA < 40) && (VA_retc))
   begin
     outfile=$fopen("./occ.err","a");
     $strobe("rmtpl    VA     entering OCA ( -40.000  V .. 40.000  V ) at %7.4r  %M", $abstime );
     $fwrite(outfile,"rmtpl    VA     entering OCA ( -40.000  V .. 40.000  V ) at %7.4r  %M\n", $abstime );
     VA_retc=0;
     $fclose(outfile);
   end

//      VB
   VB = V_B;
   if((VB < -40) && (!VB_retc))
   begin
     outfile=$fopen("./occ.err","a");
     $strobe("rmtpl    VB     leaving  OCA ( < -40.000  V )            at %7.4r  %M", $abstime );
     $fwrite(outfile,"rmtpl    VB     leaving  OCA ( < -40.000  V )            at %7.4r  %M\n", $abstime );
     VB_retc=1;
     $fclose(outfile);
   end
   if((VB > 40) && (!VB_retc))
   begin
     outfile=$fopen("./occ.err","a");
     $strobe("rmtpl    VB     leaving  OCA ( > 40.000  V )             at %7.4r  %M", $abstime );
     $fwrite(outfile,"rmtpl    VB     leaving  OCA ( > 40.000  V )             at %7.4r  %M\n", $abstime );
     VB_retc=1;
     $fclose(outfile);
   end
   if((VB > -40) && (VB < 40) && (VB_retc))
   begin
     outfile=$fopen("./occ.err","a");
     $strobe("rmtpl    VB     entering OCA ( -40.000  V .. 40.000  V ) at %7.4r  %M", $abstime );
     $fwrite(outfile,"rmtpl    VB     entering OCA ( -40.000  V .. 40.000  V ) at %7.4r  %M\n", $abstime );
     VB_retc=0;
     $fclose(outfile);
   end

end // analog
endmodule // rmtpl

// Verilog-A OC Watch for device rnp1 Parameters  VA VB
module rnp1_ahdl(A,B);
parameter tstep_occ=100n;
inout A,B;
electrical A,B;

integer outfile;
real V_B;
real V_A;
real VA;
integer VA_retc;
real VB;
integer VB_retc;

analog begin

   $bound_step( tstep_occ );
   @(initial_step) begin
      VA_retc=0;
      VB_retc=0;
   end
   V_B = V(B);
   V_A = V(A);

//      VA
   VA = V_A;
   if((VA < -40) && (!VA_retc))
   begin
     outfile=$fopen("./occ.err","a");
     $strobe("rnp1     VA     leaving  OCA ( < -40.000  V )            at %7.4r  %M", $abstime );
     $fwrite(outfile,"rnp1     VA     leaving  OCA ( < -40.000  V )            at %7.4r  %M\n", $abstime );
     VA_retc=1;
     $fclose(outfile);
   end
   if((VA > 40) && (!VA_retc))
   begin
     outfile=$fopen("./occ.err","a");
     $strobe("rnp1     VA     leaving  OCA ( > 40.000  V )             at %7.4r  %M", $abstime );
     $fwrite(outfile,"rnp1     VA     leaving  OCA ( > 40.000  V )             at %7.4r  %M\n", $abstime );
     VA_retc=1;
     $fclose(outfile);
   end
   if((VA > -40) && (VA < 40) && (VA_retc))
   begin
     outfile=$fopen("./occ.err","a");
     $strobe("rnp1     VA     entering OCA ( -40.000  V .. 40.000  V ) at %7.4r  %M", $abstime );
     $fwrite(outfile,"rnp1     VA     entering OCA ( -40.000  V .. 40.000  V ) at %7.4r  %M\n", $abstime );
     VA_retc=0;
     $fclose(outfile);
   end

//      VB
   VB = V_B;
   if((VB < -40) && (!VB_retc))
   begin
     outfile=$fopen("./occ.err","a");
     $strobe("rnp1     VB     leaving  OCA ( < -40.000  V )            at %7.4r  %M", $abstime );
     $fwrite(outfile,"rnp1     VB     leaving  OCA ( < -40.000  V )            at %7.4r  %M\n", $abstime );
     VB_retc=1;
     $fclose(outfile);
   end
   if((VB > 40) && (!VB_retc))
   begin
     outfile=$fopen("./occ.err","a");
     $strobe("rnp1     VB     leaving  OCA ( > 40.000  V )             at %7.4r  %M", $abstime );
     $fwrite(outfile,"rnp1     VB     leaving  OCA ( > 40.000  V )             at %7.4r  %M\n", $abstime );
     VB_retc=1;
     $fclose(outfile);
   end
   if((VB > -40) && (VB < 40) && (VB_retc))
   begin
     outfile=$fopen("./occ.err","a");
     $strobe("rnp1     VB     entering OCA ( -40.000  V .. 40.000  V ) at %7.4r  %M", $abstime );
     $fwrite(outfile,"rnp1     VB     entering OCA ( -40.000  V .. 40.000  V ) at %7.4r  %M\n", $abstime );
     VB_retc=0;
     $fclose(outfile);
   end

end // analog
endmodule // rnp1

// Verilog-A OC Watch for device rpp1 Parameters  VA VB
module rpp1_ahdl(A,B);
parameter tstep_occ=100n;
inout A,B;
electrical A,B;

integer outfile;
real V_B;
real V_A;
real VA;
integer VA_retc;
real VB;
integer VB_retc;

analog begin

   $bound_step( tstep_occ );
   @(initial_step) begin
      VA_retc=0;
      VB_retc=0;
   end
   V_B = V(B);
   V_A = V(A);

//      VA
   VA = V_A;
   if((VA < -40) && (!VA_retc))
   begin
     outfile=$fopen("./occ.err","a");
     $strobe("rpp1     VA     leaving  OCA ( < -40.000  V )            at %7.4r  %M", $abstime );
     $fwrite(outfile,"rpp1     VA     leaving  OCA ( < -40.000  V )            at %7.4r  %M\n", $abstime );
     VA_retc=1;
     $fclose(outfile);
   end
   if((VA > 40) && (!VA_retc))
   begin
     outfile=$fopen("./occ.err","a");
     $strobe("rpp1     VA     leaving  OCA ( > 40.000  V )             at %7.4r  %M", $abstime );
     $fwrite(outfile,"rpp1     VA     leaving  OCA ( > 40.000  V )             at %7.4r  %M\n", $abstime );
     VA_retc=1;
     $fclose(outfile);
   end
   if((VA > -40) && (VA < 40) && (VA_retc))
   begin
     outfile=$fopen("./occ.err","a");
     $strobe("rpp1     VA     entering OCA ( -40.000  V .. 40.000  V ) at %7.4r  %M", $abstime );
     $fwrite(outfile,"rpp1     VA     entering OCA ( -40.000  V .. 40.000  V ) at %7.4r  %M\n", $abstime );
     VA_retc=0;
     $fclose(outfile);
   end

//      VB
   VB = V_B;
   if((VB < -40) && (!VB_retc))
   begin
     outfile=$fopen("./occ.err","a");
     $strobe("rpp1     VB     leaving  OCA ( < -40.000  V )            at %7.4r  %M", $abstime );
     $fwrite(outfile,"rpp1     VB     leaving  OCA ( < -40.000  V )            at %7.4r  %M\n", $abstime );
     VB_retc=1;
     $fclose(outfile);
   end
   if((VB > 40) && (!VB_retc))
   begin
     outfile=$fopen("./occ.err","a");
     $strobe("rpp1     VB     leaving  OCA ( > 40.000  V )             at %7.4r  %M", $abstime );
     $fwrite(outfile,"rpp1     VB     leaving  OCA ( > 40.000  V )             at %7.4r  %M\n", $abstime );
     VB_retc=1;
     $fclose(outfile);
   end
   if((VB > -40) && (VB < 40) && (VB_retc))
   begin
     outfile=$fopen("./occ.err","a");
     $strobe("rpp1     VB     entering OCA ( -40.000  V .. 40.000  V ) at %7.4r  %M", $abstime );
     $fwrite(outfile,"rpp1     VB     entering OCA ( -40.000  V .. 40.000  V ) at %7.4r  %M\n", $abstime );
     VB_retc=0;
     $fclose(outfile);
   end

end // analog
endmodule // rpp1

// Verilog-A OC Watch for device rpp1s Parameters  VA VB
module rpp1s_ahdl(A,B);
parameter tstep_occ=100n;
inout A,B;
electrical A,B;

integer outfile;
real V_B;
real V_A;
real VA;
integer VA_retc;
real VB;
integer VB_retc;

analog begin

   $bound_step( tstep_occ );
   @(initial_step) begin
      VA_retc=0;
      VB_retc=0;
   end
   V_B = V(B);
   V_A = V(A);

//      VA
   VA = V_A;
   if((VA < -40) && (!VA_retc))
   begin
     outfile=$fopen("./occ.err","a");
     $strobe("rpp1s    VA     leaving  OCA ( < -40.000  V )            at %7.4r  %M", $abstime );
     $fwrite(outfile,"rpp1s    VA     leaving  OCA ( < -40.000  V )            at %7.4r  %M\n", $abstime );
     VA_retc=1;
     $fclose(outfile);
   end
   if((VA > 40) && (!VA_retc))
   begin
     outfile=$fopen("./occ.err","a");
     $strobe("rpp1s    VA     leaving  OCA ( > 40.000  V )             at %7.4r  %M", $abstime );
     $fwrite(outfile,"rpp1s    VA     leaving  OCA ( > 40.000  V )             at %7.4r  %M\n", $abstime );
     VA_retc=1;
     $fclose(outfile);
   end
   if((VA > -40) && (VA < 40) && (VA_retc))
   begin
     outfile=$fopen("./occ.err","a");
     $strobe("rpp1s    VA     entering OCA ( -40.000  V .. 40.000  V ) at %7.4r  %M", $abstime );
     $fwrite(outfile,"rpp1s    VA     entering OCA ( -40.000  V .. 40.000  V ) at %7.4r  %M\n", $abstime );
     VA_retc=0;
     $fclose(outfile);
   end

//      VB
   VB = V_B;
   if((VB < -40) && (!VB_retc))
   begin
     outfile=$fopen("./occ.err","a");
     $strobe("rpp1s    VB     leaving  OCA ( < -40.000  V )            at %7.4r  %M", $abstime );
     $fwrite(outfile,"rpp1s    VB     leaving  OCA ( < -40.000  V )            at %7.4r  %M\n", $abstime );
     VB_retc=1;
     $fclose(outfile);
   end
   if((VB > 40) && (!VB_retc))
   begin
     outfile=$fopen("./occ.err","a");
     $strobe("rpp1s    VB     leaving  OCA ( > 40.000  V )             at %7.4r  %M", $abstime );
     $fwrite(outfile,"rpp1s    VB     leaving  OCA ( > 40.000  V )             at %7.4r  %M\n", $abstime );
     VB_retc=1;
     $fclose(outfile);
   end
   if((VB > -40) && (VB < 40) && (VB_retc))
   begin
     outfile=$fopen("./occ.err","a");
     $strobe("rpp1s    VB     entering OCA ( -40.000  V .. 40.000  V ) at %7.4r  %M", $abstime );
     $fwrite(outfile,"rpp1s    VB     entering OCA ( -40.000  V .. 40.000  V ) at %7.4r  %M\n", $abstime );
     VB_retc=0;
     $fclose(outfile);
   end

end // analog
endmodule // rpp1s

// Verilog-A OC Watch for device rnp1h Parameters  VA VB
module rnp1h_ahdl(A,B);
parameter tstep_occ=100n;
inout A,B;
electrical A,B;

integer outfile;
real V_B;
real V_A;
real VA;
integer VA_retc;
real VB;
integer VB_retc;

analog begin

   $bound_step( tstep_occ );
   @(initial_step) begin
      VA_retc=0;
      VB_retc=0;
   end
   V_B = V(B);
   V_A = V(A);

//      VA
   VA = V_A;
   if((VA < -40) && (!VA_retc))
   begin
     outfile=$fopen("./occ.err","a");
     $strobe("rnp1h    VA     leaving  OCA ( < -40.000  V )            at %7.4r  %M", $abstime );
     $fwrite(outfile,"rnp1h    VA     leaving  OCA ( < -40.000  V )            at %7.4r  %M\n", $abstime );
     VA_retc=1;
     $fclose(outfile);
   end
   if((VA > 40) && (!VA_retc))
   begin
     outfile=$fopen("./occ.err","a");
     $strobe("rnp1h    VA     leaving  OCA ( > 40.000  V )             at %7.4r  %M", $abstime );
     $fwrite(outfile,"rnp1h    VA     leaving  OCA ( > 40.000  V )             at %7.4r  %M\n", $abstime );
     VA_retc=1;
     $fclose(outfile);
   end
   if((VA > -40) && (VA < 40) && (VA_retc))
   begin
     outfile=$fopen("./occ.err","a");
     $strobe("rnp1h    VA     entering OCA ( -40.000  V .. 40.000  V ) at %7.4r  %M", $abstime );
     $fwrite(outfile,"rnp1h    VA     entering OCA ( -40.000  V .. 40.000  V ) at %7.4r  %M\n", $abstime );
     VA_retc=0;
     $fclose(outfile);
   end

//      VB
   VB = V_B;
   if((VB < -40) && (!VB_retc))
   begin
     outfile=$fopen("./occ.err","a");
     $strobe("rnp1h    VB     leaving  OCA ( < -40.000  V )            at %7.4r  %M", $abstime );
     $fwrite(outfile,"rnp1h    VB     leaving  OCA ( < -40.000  V )            at %7.4r  %M\n", $abstime );
     VB_retc=1;
     $fclose(outfile);
   end
   if((VB > 40) && (!VB_retc))
   begin
     outfile=$fopen("./occ.err","a");
     $strobe("rnp1h    VB     leaving  OCA ( > 40.000  V )             at %7.4r  %M", $abstime );
     $fwrite(outfile,"rnp1h    VB     leaving  OCA ( > 40.000  V )             at %7.4r  %M\n", $abstime );
     VB_retc=1;
     $fclose(outfile);
   end
   if((VB > -40) && (VB < 40) && (VB_retc))
   begin
     outfile=$fopen("./occ.err","a");
     $strobe("rnp1h    VB     entering OCA ( -40.000  V .. 40.000  V ) at %7.4r  %M", $abstime );
     $fwrite(outfile,"rnp1h    VB     entering OCA ( -40.000  V .. 40.000  V ) at %7.4r  %M\n", $abstime );
     VB_retc=0;
     $fclose(outfile);
   end

end // analog
endmodule // rnp1h

// Verilog-A OC Watch for device cmm Parameters  VT VB VTB
module cmm_ahdl(T,B);
parameter tstep_occ=100n;
inout T,B;
electrical T,B;

integer outfile;
real V_T_B;
real V_B;
real V_T;
real VT;
integer VT_retc;
real VB;
integer VB_retc;
real VTB;
integer VTB_retc;

analog begin

   $bound_step( tstep_occ );
   @(initial_step) begin
      VT_retc=0;
      VB_retc=0;
      VTB_retc=0;
   end
   V_T_B = V(T,B);
   V_B = V(B);
   V_T = V(T);

//      VT
   VT = V_T;
   if((VT < -40) && (!VT_retc))
   begin
     outfile=$fopen("./occ.err","a");
     $strobe("cmm      VT     leaving  OCA ( < -40.000  V )            at %7.4r  %M", $abstime );
     $fwrite(outfile,"cmm      VT     leaving  OCA ( < -40.000  V )            at %7.4r  %M\n", $abstime );
     VT_retc=1;
     $fclose(outfile);
   end
   if((VT > 40) && (!VT_retc))
   begin
     outfile=$fopen("./occ.err","a");
     $strobe("cmm      VT     leaving  OCA ( > 40.000  V )             at %7.4r  %M", $abstime );
     $fwrite(outfile,"cmm      VT     leaving  OCA ( > 40.000  V )             at %7.4r  %M\n", $abstime );
     VT_retc=1;
     $fclose(outfile);
   end
   if((VT > -40) && (VT < 40) && (VT_retc))
   begin
     outfile=$fopen("./occ.err","a");
     $strobe("cmm      VT     entering OCA ( -40.000  V .. 40.000  V ) at %7.4r  %M", $abstime );
     $fwrite(outfile,"cmm      VT     entering OCA ( -40.000  V .. 40.000  V ) at %7.4r  %M\n", $abstime );
     VT_retc=0;
     $fclose(outfile);
   end

//      VB
   VB = V_B;
   if((VB < -40) && (!VB_retc))
   begin
     outfile=$fopen("./occ.err","a");
     $strobe("cmm      VB     leaving  OCA ( < -40.000  V )            at %7.4r  %M", $abstime );
     $fwrite(outfile,"cmm      VB     leaving  OCA ( < -40.000  V )            at %7.4r  %M\n", $abstime );
     VB_retc=1;
     $fclose(outfile);
   end
   if((VB > 40) && (!VB_retc))
   begin
     outfile=$fopen("./occ.err","a");
     $strobe("cmm      VB     leaving  OCA ( > 40.000  V )             at %7.4r  %M", $abstime );
     $fwrite(outfile,"cmm      VB     leaving  OCA ( > 40.000  V )             at %7.4r  %M\n", $abstime );
     VB_retc=1;
     $fclose(outfile);
   end
   if((VB > -40) && (VB < 40) && (VB_retc))
   begin
     outfile=$fopen("./occ.err","a");
     $strobe("cmm      VB     entering OCA ( -40.000  V .. 40.000  V ) at %7.4r  %M", $abstime );
     $fwrite(outfile,"cmm      VB     entering OCA ( -40.000  V .. 40.000  V ) at %7.4r  %M\n", $abstime );
     VB_retc=0;
     $fclose(outfile);
   end

//      VTB
   VTB = V_T_B;
   if((VTB < -5.5) && (!VTB_retc))
   begin
     outfile=$fopen("./occ.err","a");
     $strobe("cmm      VTB    leaving  OCA ( < -5.500  V )             at %7.4r  %M", $abstime );
     $fwrite(outfile,"cmm      VTB    leaving  OCA ( < -5.500  V )             at %7.4r  %M\n", $abstime );
     VTB_retc=1;
     $fclose(outfile);
   end
   if((VTB > 5.5) && (!VTB_retc))
   begin
     outfile=$fopen("./occ.err","a");
     $strobe("cmm      VTB    leaving  OCA ( > 5.500  V )              at %7.4r  %M", $abstime );
     $fwrite(outfile,"cmm      VTB    leaving  OCA ( > 5.500  V )              at %7.4r  %M\n", $abstime );
     VTB_retc=1;
     $fclose(outfile);
   end
   if((VTB > -5.5) && (VTB < 5.5) && (VTB_retc))
   begin
     outfile=$fopen("./occ.err","a");
     $strobe("cmm      VTB    entering OCA ( -5.500  V .. 5.500  V )   at %7.4r  %M", $abstime );
     $fwrite(outfile,"cmm      VTB    entering OCA ( -5.500  V .. 5.500  V )   at %7.4r  %M\n", $abstime );
     VTB_retc=0;
     $fclose(outfile);
   end

end // analog
endmodule // cmm

// Verilog-A OC Watch for device cdmm Parameters  VT VB VTB
module cdmm_ahdl(T,B);
parameter tstep_occ=100n;
inout T,B;
electrical T,B;

integer outfile;
real V_T_B;
real V_B;
real V_T;
real VT;
integer VT_retc;
real VB;
integer VB_retc;
real VTB;
integer VTB_retc;

analog begin

   $bound_step( tstep_occ );
   @(initial_step) begin
      VT_retc=0;
      VB_retc=0;
      VTB_retc=0;
   end
   V_T_B = V(T,B);
   V_B = V(B);
   V_T = V(T);

//      VT
   VT = V_T;
   if((VT < -40) && (!VT_retc))
   begin
     outfile=$fopen("./occ.err","a");
     $strobe("cdmm     VT     leaving  OCA ( < -40.000  V )            at %7.4r  %M", $abstime );
     $fwrite(outfile,"cdmm     VT     leaving  OCA ( < -40.000  V )            at %7.4r  %M\n", $abstime );
     VT_retc=1;
     $fclose(outfile);
   end
   if((VT > 40) && (!VT_retc))
   begin
     outfile=$fopen("./occ.err","a");
     $strobe("cdmm     VT     leaving  OCA ( > 40.000  V )             at %7.4r  %M", $abstime );
     $fwrite(outfile,"cdmm     VT     leaving  OCA ( > 40.000  V )             at %7.4r  %M\n", $abstime );
     VT_retc=1;
     $fclose(outfile);
   end
   if((VT > -40) && (VT < 40) && (VT_retc))
   begin
     outfile=$fopen("./occ.err","a");
     $strobe("cdmm     VT     entering OCA ( -40.000  V .. 40.000  V ) at %7.4r  %M", $abstime );
     $fwrite(outfile,"cdmm     VT     entering OCA ( -40.000  V .. 40.000  V ) at %7.4r  %M\n", $abstime );
     VT_retc=0;
     $fclose(outfile);
   end

//      VB
   VB = V_B;
   if((VB < -40) && (!VB_retc))
   begin
     outfile=$fopen("./occ.err","a");
     $strobe("cdmm     VB     leaving  OCA ( < -40.000  V )            at %7.4r  %M", $abstime );
     $fwrite(outfile,"cdmm     VB     leaving  OCA ( < -40.000  V )            at %7.4r  %M\n", $abstime );
     VB_retc=1;
     $fclose(outfile);
   end
   if((VB > 40) && (!VB_retc))
   begin
     outfile=$fopen("./occ.err","a");
     $strobe("cdmm     VB     leaving  OCA ( > 40.000  V )             at %7.4r  %M", $abstime );
     $fwrite(outfile,"cdmm     VB     leaving  OCA ( > 40.000  V )             at %7.4r  %M\n", $abstime );
     VB_retc=1;
     $fclose(outfile);
   end
   if((VB > -40) && (VB < 40) && (VB_retc))
   begin
     outfile=$fopen("./occ.err","a");
     $strobe("cdmm     VB     entering OCA ( -40.000  V .. 40.000  V ) at %7.4r  %M", $abstime );
     $fwrite(outfile,"cdmm     VB     entering OCA ( -40.000  V .. 40.000  V ) at %7.4r  %M\n", $abstime );
     VB_retc=0;
     $fclose(outfile);
   end

//      VTB
   VTB = V_T_B;
   if((VTB < -5.5) && (!VTB_retc))
   begin
     outfile=$fopen("./occ.err","a");
     $strobe("cdmm     VTB    leaving  OCA ( < -5.500  V )             at %7.4r  %M", $abstime );
     $fwrite(outfile,"cdmm     VTB    leaving  OCA ( < -5.500  V )             at %7.4r  %M\n", $abstime );
     VTB_retc=1;
     $fclose(outfile);
   end
   if((VTB > 5.5) && (!VTB_retc))
   begin
     outfile=$fopen("./occ.err","a");
     $strobe("cdmm     VTB    leaving  OCA ( > 5.500  V )              at %7.4r  %M", $abstime );
     $fwrite(outfile,"cdmm     VTB    leaving  OCA ( > 5.500  V )              at %7.4r  %M\n", $abstime );
     VTB_retc=1;
     $fclose(outfile);
   end
   if((VTB > -5.5) && (VTB < 5.5) && (VTB_retc))
   begin
     outfile=$fopen("./occ.err","a");
     $strobe("cdmm     VTB    entering OCA ( -5.500  V .. 5.500  V )   at %7.4r  %M", $abstime );
     $fwrite(outfile,"cdmm     VTB    entering OCA ( -5.500  V .. 5.500  V )   at %7.4r  %M\n", $abstime );
     VTB_retc=0;
     $fclose(outfile);
   end

end // analog
endmodule // cdmm

// Verilog-A OC Watch for device ctmm Parameters  VT VB VTB
module ctmm_ahdl(T,B);
parameter tstep_occ=100n;
inout T,B;
electrical T,B;

integer outfile;
real V_T_B;
real V_B;
real V_T;
real VT;
integer VT_retc;
real VB;
integer VB_retc;
real VTB;
integer VTB_retc;

analog begin

   $bound_step( tstep_occ );
   @(initial_step) begin
      VT_retc=0;
      VB_retc=0;
      VTB_retc=0;
   end
   V_T_B = V(T,B);
   V_B = V(B);
   V_T = V(T);

//      VT
   VT = V_T;
   if((VT < -40) && (!VT_retc))
   begin
     outfile=$fopen("./occ.err","a");
     $strobe("ctmm     VT     leaving  OCA ( < -40.000  V )            at %7.4r  %M", $abstime );
     $fwrite(outfile,"ctmm     VT     leaving  OCA ( < -40.000  V )            at %7.4r  %M\n", $abstime );
     VT_retc=1;
     $fclose(outfile);
   end
   if((VT > 40) && (!VT_retc))
   begin
     outfile=$fopen("./occ.err","a");
     $strobe("ctmm     VT     leaving  OCA ( > 40.000  V )             at %7.4r  %M", $abstime );
     $fwrite(outfile,"ctmm     VT     leaving  OCA ( > 40.000  V )             at %7.4r  %M\n", $abstime );
     VT_retc=1;
     $fclose(outfile);
   end
   if((VT > -40) && (VT < 40) && (VT_retc))
   begin
     outfile=$fopen("./occ.err","a");
     $strobe("ctmm     VT     entering OCA ( -40.000  V .. 40.000  V ) at %7.4r  %M", $abstime );
     $fwrite(outfile,"ctmm     VT     entering OCA ( -40.000  V .. 40.000  V ) at %7.4r  %M\n", $abstime );
     VT_retc=0;
     $fclose(outfile);
   end

//      VB
   VB = V_B;
   if((VB < -40) && (!VB_retc))
   begin
     outfile=$fopen("./occ.err","a");
     $strobe("ctmm     VB     leaving  OCA ( < -40.000  V )            at %7.4r  %M", $abstime );
     $fwrite(outfile,"ctmm     VB     leaving  OCA ( < -40.000  V )            at %7.4r  %M\n", $abstime );
     VB_retc=1;
     $fclose(outfile);
   end
   if((VB > 40) && (!VB_retc))
   begin
     outfile=$fopen("./occ.err","a");
     $strobe("ctmm     VB     leaving  OCA ( > 40.000  V )             at %7.4r  %M", $abstime );
     $fwrite(outfile,"ctmm     VB     leaving  OCA ( > 40.000  V )             at %7.4r  %M\n", $abstime );
     VB_retc=1;
     $fclose(outfile);
   end
   if((VB > -40) && (VB < 40) && (VB_retc))
   begin
     outfile=$fopen("./occ.err","a");
     $strobe("ctmm     VB     entering OCA ( -40.000  V .. 40.000  V ) at %7.4r  %M", $abstime );
     $fwrite(outfile,"ctmm     VB     entering OCA ( -40.000  V .. 40.000  V ) at %7.4r  %M\n", $abstime );
     VB_retc=0;
     $fclose(outfile);
   end

//      VTB
   VTB = V_T_B;
   if((VTB < -5.5) && (!VTB_retc))
   begin
     outfile=$fopen("./occ.err","a");
     $strobe("ctmm     VTB    leaving  OCA ( < -5.500  V )             at %7.4r  %M", $abstime );
     $fwrite(outfile,"ctmm     VTB    leaving  OCA ( < -5.500  V )             at %7.4r  %M\n", $abstime );
     VTB_retc=1;
     $fclose(outfile);
   end
   if((VTB > 5.5) && (!VTB_retc))
   begin
     outfile=$fopen("./occ.err","a");
     $strobe("ctmm     VTB    leaving  OCA ( > 5.500  V )              at %7.4r  %M", $abstime );
     $fwrite(outfile,"ctmm     VTB    leaving  OCA ( > 5.500  V )              at %7.4r  %M\n", $abstime );
     VTB_retc=1;
     $fclose(outfile);
   end
   if((VTB > -5.5) && (VTB < 5.5) && (VTB_retc))
   begin
     outfile=$fopen("./occ.err","a");
     $strobe("ctmm     VTB    entering OCA ( -5.500  V .. 5.500  V )   at %7.4r  %M", $abstime );
     $fwrite(outfile,"ctmm     VTB    entering OCA ( -5.500  V .. 5.500  V )   at %7.4r  %M\n", $abstime );
     VTB_retc=0;
     $fclose(outfile);
   end

end // analog
endmodule // ctmm

// Verilog-A OC Watch for device csandwt3 Parameters  VT VB VTB
module csandwt3_ahdl(T,B);
parameter tstep_occ=100n;
inout T,B;
electrical T,B;

integer outfile;
real V_T_B;
real V_B;
real V_T;
real VT;
integer VT_retc;
real VB;
integer VB_retc;
real VTB;
integer VTB_retc;

analog begin

   $bound_step( tstep_occ );
   @(initial_step) begin
      VT_retc=0;
      VB_retc=0;
      VTB_retc=0;
   end
   V_T_B = V(T,B);
   V_B = V(B);
   V_T = V(T);

//      VT
   VT = V_T;
   if((VT < -40) && (!VT_retc))
   begin
     outfile=$fopen("./occ.err","a");
     $strobe("csandwt3 VT     leaving  OCA ( < -40.000  V )            at %7.4r  %M", $abstime );
     $fwrite(outfile,"csandwt3 VT     leaving  OCA ( < -40.000  V )            at %7.4r  %M\n", $abstime );
     VT_retc=1;
     $fclose(outfile);
   end
   if((VT > 40) && (!VT_retc))
   begin
     outfile=$fopen("./occ.err","a");
     $strobe("csandwt3 VT     leaving  OCA ( > 40.000  V )             at %7.4r  %M", $abstime );
     $fwrite(outfile,"csandwt3 VT     leaving  OCA ( > 40.000  V )             at %7.4r  %M\n", $abstime );
     VT_retc=1;
     $fclose(outfile);
   end
   if((VT > -40) && (VT < 40) && (VT_retc))
   begin
     outfile=$fopen("./occ.err","a");
     $strobe("csandwt3 VT     entering OCA ( -40.000  V .. 40.000  V ) at %7.4r  %M", $abstime );
     $fwrite(outfile,"csandwt3 VT     entering OCA ( -40.000  V .. 40.000  V ) at %7.4r  %M\n", $abstime );
     VT_retc=0;
     $fclose(outfile);
   end

//      VB
   VB = V_B;
   if((VB < -40) && (!VB_retc))
   begin
     outfile=$fopen("./occ.err","a");
     $strobe("csandwt3 VB     leaving  OCA ( < -40.000  V )            at %7.4r  %M", $abstime );
     $fwrite(outfile,"csandwt3 VB     leaving  OCA ( < -40.000  V )            at %7.4r  %M\n", $abstime );
     VB_retc=1;
     $fclose(outfile);
   end
   if((VB > 40) && (!VB_retc))
   begin
     outfile=$fopen("./occ.err","a");
     $strobe("csandwt3 VB     leaving  OCA ( > 40.000  V )             at %7.4r  %M", $abstime );
     $fwrite(outfile,"csandwt3 VB     leaving  OCA ( > 40.000  V )             at %7.4r  %M\n", $abstime );
     VB_retc=1;
     $fclose(outfile);
   end
   if((VB > -40) && (VB < 40) && (VB_retc))
   begin
     outfile=$fopen("./occ.err","a");
     $strobe("csandwt3 VB     entering OCA ( -40.000  V .. 40.000  V ) at %7.4r  %M", $abstime );
     $fwrite(outfile,"csandwt3 VB     entering OCA ( -40.000  V .. 40.000  V ) at %7.4r  %M\n", $abstime );
     VB_retc=0;
     $fclose(outfile);
   end

//      VTB
   VTB = V_T_B;
   if((VTB < -40) && (!VTB_retc))
   begin
     outfile=$fopen("./occ.err","a");
     $strobe("csandwt3 VTB    leaving  OCA ( < -40.000  V )            at %7.4r  %M", $abstime );
     $fwrite(outfile,"csandwt3 VTB    leaving  OCA ( < -40.000  V )            at %7.4r  %M\n", $abstime );
     VTB_retc=1;
     $fclose(outfile);
   end
   if((VTB > 40) && (!VTB_retc))
   begin
     outfile=$fopen("./occ.err","a");
     $strobe("csandwt3 VTB    leaving  OCA ( > 40.000  V )             at %7.4r  %M", $abstime );
     $fwrite(outfile,"csandwt3 VTB    leaving  OCA ( > 40.000  V )             at %7.4r  %M\n", $abstime );
     VTB_retc=1;
     $fclose(outfile);
   end
   if((VTB > -40) && (VTB < 40) && (VTB_retc))
   begin
     outfile=$fopen("./occ.err","a");
     $strobe("csandwt3 VTB    entering OCA ( -40.000  V .. 40.000  V ) at %7.4r  %M", $abstime );
     $fwrite(outfile,"csandwt3 VTB    entering OCA ( -40.000  V .. 40.000  V ) at %7.4r  %M\n", $abstime );
     VTB_retc=0;
     $fclose(outfile);
   end

end // analog
endmodule // csandwt3

// Verilog-A OC Watch for device csandwt4 Parameters  VT VB VTB
module csandwt4_ahdl(T,B);
parameter tstep_occ=100n;
inout T,B;
electrical T,B;

integer outfile;
real V_T_B;
real V_B;
real V_T;
real VT;
integer VT_retc;
real VB;
integer VB_retc;
real VTB;
integer VTB_retc;

analog begin

   $bound_step( tstep_occ );
   @(initial_step) begin
      VT_retc=0;
      VB_retc=0;
      VTB_retc=0;
   end
   V_T_B = V(T,B);
   V_B = V(B);
   V_T = V(T);

//      VT
   VT = V_T;
   if((VT < -40) && (!VT_retc))
   begin
     outfile=$fopen("./occ.err","a");
     $strobe("csandwt4 VT     leaving  OCA ( < -40.000  V )            at %7.4r  %M", $abstime );
     $fwrite(outfile,"csandwt4 VT     leaving  OCA ( < -40.000  V )            at %7.4r  %M\n", $abstime );
     VT_retc=1;
     $fclose(outfile);
   end
   if((VT > 40) && (!VT_retc))
   begin
     outfile=$fopen("./occ.err","a");
     $strobe("csandwt4 VT     leaving  OCA ( > 40.000  V )             at %7.4r  %M", $abstime );
     $fwrite(outfile,"csandwt4 VT     leaving  OCA ( > 40.000  V )             at %7.4r  %M\n", $abstime );
     VT_retc=1;
     $fclose(outfile);
   end
   if((VT > -40) && (VT < 40) && (VT_retc))
   begin
     outfile=$fopen("./occ.err","a");
     $strobe("csandwt4 VT     entering OCA ( -40.000  V .. 40.000  V ) at %7.4r  %M", $abstime );
     $fwrite(outfile,"csandwt4 VT     entering OCA ( -40.000  V .. 40.000  V ) at %7.4r  %M\n", $abstime );
     VT_retc=0;
     $fclose(outfile);
   end

//      VB
   VB = V_B;
   if((VB < -40) && (!VB_retc))
   begin
     outfile=$fopen("./occ.err","a");
     $strobe("csandwt4 VB     leaving  OCA ( < -40.000  V )            at %7.4r  %M", $abstime );
     $fwrite(outfile,"csandwt4 VB     leaving  OCA ( < -40.000  V )            at %7.4r  %M\n", $abstime );
     VB_retc=1;
     $fclose(outfile);
   end
   if((VB > 40) && (!VB_retc))
   begin
     outfile=$fopen("./occ.err","a");
     $strobe("csandwt4 VB     leaving  OCA ( > 40.000  V )             at %7.4r  %M", $abstime );
     $fwrite(outfile,"csandwt4 VB     leaving  OCA ( > 40.000  V )             at %7.4r  %M\n", $abstime );
     VB_retc=1;
     $fclose(outfile);
   end
   if((VB > -40) && (VB < 40) && (VB_retc))
   begin
     outfile=$fopen("./occ.err","a");
     $strobe("csandwt4 VB     entering OCA ( -40.000  V .. 40.000  V ) at %7.4r  %M", $abstime );
     $fwrite(outfile,"csandwt4 VB     entering OCA ( -40.000  V .. 40.000  V ) at %7.4r  %M\n", $abstime );
     VB_retc=0;
     $fclose(outfile);
   end

//      VTB
   VTB = V_T_B;
   if((VTB < -40) && (!VTB_retc))
   begin
     outfile=$fopen("./occ.err","a");
     $strobe("csandwt4 VTB    leaving  OCA ( < -40.000  V )            at %7.4r  %M", $abstime );
     $fwrite(outfile,"csandwt4 VTB    leaving  OCA ( < -40.000  V )            at %7.4r  %M\n", $abstime );
     VTB_retc=1;
     $fclose(outfile);
   end
   if((VTB > 40) && (!VTB_retc))
   begin
     outfile=$fopen("./occ.err","a");
     $strobe("csandwt4 VTB    leaving  OCA ( > 40.000  V )             at %7.4r  %M", $abstime );
     $fwrite(outfile,"csandwt4 VTB    leaving  OCA ( > 40.000  V )             at %7.4r  %M\n", $abstime );
     VTB_retc=1;
     $fclose(outfile);
   end
   if((VTB > -40) && (VTB < 40) && (VTB_retc))
   begin
     outfile=$fopen("./occ.err","a");
     $strobe("csandwt4 VTB    entering OCA ( -40.000  V .. 40.000  V ) at %7.4r  %M", $abstime );
     $fwrite(outfile,"csandwt4 VTB    entering OCA ( -40.000  V .. 40.000  V ) at %7.4r  %M\n", $abstime );
     VTB_retc=0;
     $fclose(outfile);
   end

end // analog
endmodule // csandwt4

// Verilog-A OC Watch for device csandwt5 Parameters  VT VB VTB
module csandwt5_ahdl(T,B);
parameter tstep_occ=100n;
inout T,B;
electrical T,B;

integer outfile;
real V_T_B;
real V_B;
real V_T;
real VT;
integer VT_retc;
real VB;
integer VB_retc;
real VTB;
integer VTB_retc;

analog begin

   $bound_step( tstep_occ );
   @(initial_step) begin
      VT_retc=0;
      VB_retc=0;
      VTB_retc=0;
   end
   V_T_B = V(T,B);
   V_B = V(B);
   V_T = V(T);

//      VT
   VT = V_T;
   if((VT < -40) && (!VT_retc))
   begin
     outfile=$fopen("./occ.err","a");
     $strobe("csandwt5 VT     leaving  OCA ( < -40.000  V )            at %7.4r  %M", $abstime );
     $fwrite(outfile,"csandwt5 VT     leaving  OCA ( < -40.000  V )            at %7.4r  %M\n", $abstime );
     VT_retc=1;
     $fclose(outfile);
   end
   if((VT > 40) && (!VT_retc))
   begin
     outfile=$fopen("./occ.err","a");
     $strobe("csandwt5 VT     leaving  OCA ( > 40.000  V )             at %7.4r  %M", $abstime );
     $fwrite(outfile,"csandwt5 VT     leaving  OCA ( > 40.000  V )             at %7.4r  %M\n", $abstime );
     VT_retc=1;
     $fclose(outfile);
   end
   if((VT > -40) && (VT < 40) && (VT_retc))
   begin
     outfile=$fopen("./occ.err","a");
     $strobe("csandwt5 VT     entering OCA ( -40.000  V .. 40.000  V ) at %7.4r  %M", $abstime );
     $fwrite(outfile,"csandwt5 VT     entering OCA ( -40.000  V .. 40.000  V ) at %7.4r  %M\n", $abstime );
     VT_retc=0;
     $fclose(outfile);
   end

//      VB
   VB = V_B;
   if((VB < -40) && (!VB_retc))
   begin
     outfile=$fopen("./occ.err","a");
     $strobe("csandwt5 VB     leaving  OCA ( < -40.000  V )            at %7.4r  %M", $abstime );
     $fwrite(outfile,"csandwt5 VB     leaving  OCA ( < -40.000  V )            at %7.4r  %M\n", $abstime );
     VB_retc=1;
     $fclose(outfile);
   end
   if((VB > 40) && (!VB_retc))
   begin
     outfile=$fopen("./occ.err","a");
     $strobe("csandwt5 VB     leaving  OCA ( > 40.000  V )             at %7.4r  %M", $abstime );
     $fwrite(outfile,"csandwt5 VB     leaving  OCA ( > 40.000  V )             at %7.4r  %M\n", $abstime );
     VB_retc=1;
     $fclose(outfile);
   end
   if((VB > -40) && (VB < 40) && (VB_retc))
   begin
     outfile=$fopen("./occ.err","a");
     $strobe("csandwt5 VB     entering OCA ( -40.000  V .. 40.000  V ) at %7.4r  %M", $abstime );
     $fwrite(outfile,"csandwt5 VB     entering OCA ( -40.000  V .. 40.000  V ) at %7.4r  %M\n", $abstime );
     VB_retc=0;
     $fclose(outfile);
   end

//      VTB
   VTB = V_T_B;
   if((VTB < -40) && (!VTB_retc))
   begin
     outfile=$fopen("./occ.err","a");
     $strobe("csandwt5 VTB    leaving  OCA ( < -40.000  V )            at %7.4r  %M", $abstime );
     $fwrite(outfile,"csandwt5 VTB    leaving  OCA ( < -40.000  V )            at %7.4r  %M\n", $abstime );
     VTB_retc=1;
     $fclose(outfile);
   end
   if((VTB > 40) && (!VTB_retc))
   begin
     outfile=$fopen("./occ.err","a");
     $strobe("csandwt5 VTB    leaving  OCA ( > 40.000  V )             at %7.4r  %M", $abstime );
     $fwrite(outfile,"csandwt5 VTB    leaving  OCA ( > 40.000  V )             at %7.4r  %M\n", $abstime );
     VTB_retc=1;
     $fclose(outfile);
   end
   if((VTB > -40) && (VTB < 40) && (VTB_retc))
   begin
     outfile=$fopen("./occ.err","a");
     $strobe("csandwt5 VTB    entering OCA ( -40.000  V .. 40.000  V ) at %7.4r  %M", $abstime );
     $fwrite(outfile,"csandwt5 VTB    entering OCA ( -40.000  V .. 40.000  V ) at %7.4r  %M\n", $abstime );
     VTB_retc=0;
     $fclose(outfile);
   end

end // analog
endmodule // csandwt5

// Verilog-A OC Watch for device dn Parameters  VAC
module dn_ahdl(A,C);
parameter tstep_occ=100n;
inout A,C;
electrical A,C;

integer outfile;
real V_A_C;
real VAC;
integer VAC_retc;

analog begin

   $bound_step( tstep_occ );
   @(initial_step) begin
      VAC_retc=0;
   end
   V_A_C = V(A,C);

//      VAC
   VAC = V_A_C;
   if((VAC < -1.98) && (!VAC_retc))
   begin
     outfile=$fopen("./occ.err","a");
     $strobe("dn       VAC    leaving  OCA ( < -1.980  V )             at %7.4r  %M", $abstime );
     $fwrite(outfile,"dn       VAC    leaving  OCA ( < -1.980  V )             at %7.4r  %M\n", $abstime );
     VAC_retc=1;
     $fclose(outfile);
   end
   if((VAC > 0.1) && (!VAC_retc))
   begin
     outfile=$fopen("./occ.err","a");
     $strobe("dn       VAC    leaving  OCA ( > 0.100  V )              at %7.4r  %M", $abstime );
     $fwrite(outfile,"dn       VAC    leaving  OCA ( > 0.100  V )              at %7.4r  %M\n", $abstime );
     VAC_retc=1;
     $fclose(outfile);
   end
   if((VAC > -1.98) && (VAC < 0.1) && (VAC_retc))
   begin
     outfile=$fopen("./occ.err","a");
     $strobe("dn       VAC    entering OCA ( -1.980  V .. 0.100  V )   at %7.4r  %M", $abstime );
     $fwrite(outfile,"dn       VAC    entering OCA ( -1.980  V .. 0.100  V )   at %7.4r  %M\n", $abstime );
     VAC_retc=0;
     $fclose(outfile);
   end

end // analog
endmodule // dn

// Verilog-A OC Watch for device dp Parameters  VAC
module dp_ahdl(A,C);
parameter tstep_occ=100n;
inout A,C;
electrical A,C;

integer outfile;
real V_A_C;
real VAC;
integer VAC_retc;

analog begin

   $bound_step( tstep_occ );
   @(initial_step) begin
      VAC_retc=0;
   end
   V_A_C = V(A,C);

//      VAC
   VAC = V_A_C;
   if((VAC < -1.98) && (!VAC_retc))
   begin
     outfile=$fopen("./occ.err","a");
     $strobe("dp       VAC    leaving  OCA ( < -1.980  V )             at %7.4r  %M", $abstime );
     $fwrite(outfile,"dp       VAC    leaving  OCA ( < -1.980  V )             at %7.4r  %M\n", $abstime );
     VAC_retc=1;
     $fclose(outfile);
   end
   if((VAC > 0.1) && (!VAC_retc))
   begin
     outfile=$fopen("./occ.err","a");
     $strobe("dp       VAC    leaving  OCA ( > 0.100  V )              at %7.4r  %M", $abstime );
     $fwrite(outfile,"dp       VAC    leaving  OCA ( > 0.100  V )              at %7.4r  %M\n", $abstime );
     VAC_retc=1;
     $fclose(outfile);
   end
   if((VAC > -1.98) && (VAC < 0.1) && (VAC_retc))
   begin
     outfile=$fopen("./occ.err","a");
     $strobe("dp       VAC    entering OCA ( -1.980  V .. 0.100  V )   at %7.4r  %M", $abstime );
     $fwrite(outfile,"dp       VAC    entering OCA ( -1.980  V .. 0.100  V )   at %7.4r  %M\n", $abstime );
     VAC_retc=0;
     $fclose(outfile);
   end

end // analog
endmodule // dp

// Verilog-A OC Watch for device dn3 Parameters  VAC
module dn3_ahdl(A,C);
parameter tstep_occ=100n;
inout A,C;
electrical A,C;

integer outfile;
real V_A_C;
real VAC;
integer VAC_retc;

analog begin

   $bound_step( tstep_occ );
   @(initial_step) begin
      VAC_retc=0;
   end
   V_A_C = V(A,C);

//      VAC
   VAC = V_A_C;
   if((VAC < -3.6) && (!VAC_retc))
   begin
     outfile=$fopen("./occ.err","a");
     $strobe("dn3      VAC    leaving  OCA ( < -3.600  V )             at %7.4r  %M", $abstime );
     $fwrite(outfile,"dn3      VAC    leaving  OCA ( < -3.600  V )             at %7.4r  %M\n", $abstime );
     VAC_retc=1;
     $fclose(outfile);
   end
   if((VAC > 0.1) && (!VAC_retc))
   begin
     outfile=$fopen("./occ.err","a");
     $strobe("dn3      VAC    leaving  OCA ( > 0.100  V )              at %7.4r  %M", $abstime );
     $fwrite(outfile,"dn3      VAC    leaving  OCA ( > 0.100  V )              at %7.4r  %M\n", $abstime );
     VAC_retc=1;
     $fclose(outfile);
   end
   if((VAC > -3.6) && (VAC < 0.1) && (VAC_retc))
   begin
     outfile=$fopen("./occ.err","a");
     $strobe("dn3      VAC    entering OCA ( -3.600  V .. 0.100  V )   at %7.4r  %M", $abstime );
     $fwrite(outfile,"dn3      VAC    entering OCA ( -3.600  V .. 0.100  V )   at %7.4r  %M\n", $abstime );
     VAC_retc=0;
     $fclose(outfile);
   end

end // analog
endmodule // dn3

// Verilog-A OC Watch for device dp3 Parameters  VAC
module dp3_ahdl(A,C);
parameter tstep_occ=100n;
inout A,C;
electrical A,C;

integer outfile;
real V_A_C;
real VAC;
integer VAC_retc;

analog begin

   $bound_step( tstep_occ );
   @(initial_step) begin
      VAC_retc=0;
   end
   V_A_C = V(A,C);

//      VAC
   VAC = V_A_C;
   if((VAC < -3.6) && (!VAC_retc))
   begin
     outfile=$fopen("./occ.err","a");
     $strobe("dp3      VAC    leaving  OCA ( < -3.600  V )             at %7.4r  %M", $abstime );
     $fwrite(outfile,"dp3      VAC    leaving  OCA ( < -3.600  V )             at %7.4r  %M\n", $abstime );
     VAC_retc=1;
     $fclose(outfile);
   end
   if((VAC > 0.1) && (!VAC_retc))
   begin
     outfile=$fopen("./occ.err","a");
     $strobe("dp3      VAC    leaving  OCA ( > 0.100  V )              at %7.4r  %M", $abstime );
     $fwrite(outfile,"dp3      VAC    leaving  OCA ( > 0.100  V )              at %7.4r  %M\n", $abstime );
     VAC_retc=1;
     $fclose(outfile);
   end
   if((VAC > -3.6) && (VAC < 0.1) && (VAC_retc))
   begin
     outfile=$fopen("./occ.err","a");
     $strobe("dp3      VAC    entering OCA ( -3.600  V .. 0.100  V )   at %7.4r  %M", $abstime );
     $fwrite(outfile,"dp3      VAC    entering OCA ( -3.600  V .. 0.100  V )   at %7.4r  %M\n", $abstime );
     VAC_retc=0;
     $fclose(outfile);
   end

end // analog
endmodule // dp3

// Verilog-A OC Watch for device dnw Parameters  VAC
module dnw_ahdl(A,C);
parameter tstep_occ=100n;
inout A,C;
electrical A,C;

integer outfile;
real V_A_C;
real VAC;
integer VAC_retc;

analog begin

   $bound_step( tstep_occ );
   @(initial_step) begin
      VAC_retc=0;
   end
   V_A_C = V(A,C);

//      VAC
   VAC = V_A_C;
   if((VAC < -5.5) && (!VAC_retc))
   begin
     outfile=$fopen("./occ.err","a");
     $strobe("dnw      VAC    leaving  OCA ( < -5.500  V )             at %7.4r  %M", $abstime );
     $fwrite(outfile,"dnw      VAC    leaving  OCA ( < -5.500  V )             at %7.4r  %M\n", $abstime );
     VAC_retc=1;
     $fclose(outfile);
   end
   if((VAC > 0.1) && (!VAC_retc))
   begin
     outfile=$fopen("./occ.err","a");
     $strobe("dnw      VAC    leaving  OCA ( > 0.100  V )              at %7.4r  %M", $abstime );
     $fwrite(outfile,"dnw      VAC    leaving  OCA ( > 0.100  V )              at %7.4r  %M\n", $abstime );
     VAC_retc=1;
     $fclose(outfile);
   end
   if((VAC > -5.5) && (VAC < 0.1) && (VAC_retc))
   begin
     outfile=$fopen("./occ.err","a");
     $strobe("dnw      VAC    entering OCA ( -5.500  V .. 0.100  V )   at %7.4r  %M", $abstime );
     $fwrite(outfile,"dnw      VAC    entering OCA ( -5.500  V .. 0.100  V )   at %7.4r  %M\n", $abstime );
     VAC_retc=0;
     $fclose(outfile);
   end

end // analog
endmodule // dnw

// Verilog-A OC Watch for device dnw3 Parameters  VAC
module dnw3_ahdl(A,C);
parameter tstep_occ=100n;
inout A,C;
electrical A,C;

integer outfile;
real V_A_C;
real VAC;
integer VAC_retc;

analog begin

   $bound_step( tstep_occ );
   @(initial_step) begin
      VAC_retc=0;
   end
   V_A_C = V(A,C);

//      VAC
   VAC = V_A_C;
   if((VAC < -5.5) && (!VAC_retc))
   begin
     outfile=$fopen("./occ.err","a");
     $strobe("dnw3     VAC    leaving  OCA ( < -5.500  V )             at %7.4r  %M", $abstime );
     $fwrite(outfile,"dnw3     VAC    leaving  OCA ( < -5.500  V )             at %7.4r  %M\n", $abstime );
     VAC_retc=1;
     $fclose(outfile);
   end
   if((VAC > 0.1) && (!VAC_retc))
   begin
     outfile=$fopen("./occ.err","a");
     $strobe("dnw3     VAC    leaving  OCA ( > 0.100  V )              at %7.4r  %M", $abstime );
     $fwrite(outfile,"dnw3     VAC    leaving  OCA ( > 0.100  V )              at %7.4r  %M\n", $abstime );
     VAC_retc=1;
     $fclose(outfile);
   end
   if((VAC > -5.5) && (VAC < 0.1) && (VAC_retc))
   begin
     outfile=$fopen("./occ.err","a");
     $strobe("dnw3     VAC    entering OCA ( -5.500  V .. 0.100  V )   at %7.4r  %M", $abstime );
     $fwrite(outfile,"dnw3     VAC    entering OCA ( -5.500  V .. 0.100  V )   at %7.4r  %M\n", $abstime );
     VAC_retc=0;
     $fclose(outfile);
   end

end // analog
endmodule // dnw3

// Verilog-A OC Watch for device dpdnw Parameters  VAC
module dpdnw_ahdl(A,C);
parameter tstep_occ=100n;
inout A,C;
electrical A,C;

integer outfile;
real V_A_C;
real VAC;
integer VAC_retc;

analog begin

   $bound_step( tstep_occ );
   @(initial_step) begin
      VAC_retc=0;
   end
   V_A_C = V(A,C);

//      VAC
   VAC = V_A_C;
   if((VAC < -5.5) && (!VAC_retc))
   begin
     outfile=$fopen("./occ.err","a");
     $strobe("dpdnw    VAC    leaving  OCA ( < -5.500  V )             at %7.4r  %M", $abstime );
     $fwrite(outfile,"dpdnw    VAC    leaving  OCA ( < -5.500  V )             at %7.4r  %M\n", $abstime );
     VAC_retc=1;
     $fclose(outfile);
   end
   if((VAC > 0.1) && (!VAC_retc))
   begin
     outfile=$fopen("./occ.err","a");
     $strobe("dpdnw    VAC    leaving  OCA ( > 0.100  V )              at %7.4r  %M", $abstime );
     $fwrite(outfile,"dpdnw    VAC    leaving  OCA ( > 0.100  V )              at %7.4r  %M\n", $abstime );
     VAC_retc=1;
     $fclose(outfile);
   end
   if((VAC > -5.5) && (VAC < 0.1) && (VAC_retc))
   begin
     outfile=$fopen("./occ.err","a");
     $strobe("dpdnw    VAC    entering OCA ( -5.500  V .. 0.100  V )   at %7.4r  %M", $abstime );
     $fwrite(outfile,"dpdnw    VAC    entering OCA ( -5.500  V .. 0.100  V )   at %7.4r  %M\n", $abstime );
     VAC_retc=0;
     $fclose(outfile);
   end

end // analog
endmodule // dpdnw

// Verilog-A OC Watch for device dnhpw Parameters  VAC
module dnhpw_ahdl(A,C);
parameter tstep_occ=100n;
inout A,C;
electrical A,C;

integer outfile;
real V_A_C;
real VAC;
integer VAC_retc;

analog begin

   $bound_step( tstep_occ );
   @(initial_step) begin
      VAC_retc=0;
   end
   V_A_C = V(A,C);

//      VAC
   VAC = V_A_C;
   if((VAC < -5.5) && (!VAC_retc))
   begin
     outfile=$fopen("./occ.err","a");
     $strobe("dnhpw    VAC    leaving  OCA ( < -5.500  V )             at %7.4r  %M", $abstime );
     $fwrite(outfile,"dnhpw    VAC    leaving  OCA ( < -5.500  V )             at %7.4r  %M\n", $abstime );
     VAC_retc=1;
     $fclose(outfile);
   end
   if((VAC > 0.1) && (!VAC_retc))
   begin
     outfile=$fopen("./occ.err","a");
     $strobe("dnhpw    VAC    leaving  OCA ( > 0.100  V )              at %7.4r  %M", $abstime );
     $fwrite(outfile,"dnhpw    VAC    leaving  OCA ( > 0.100  V )              at %7.4r  %M\n", $abstime );
     VAC_retc=1;
     $fclose(outfile);
   end
   if((VAC > -5.5) && (VAC < 0.1) && (VAC_retc))
   begin
     outfile=$fopen("./occ.err","a");
     $strobe("dnhpw    VAC    entering OCA ( -5.500  V .. 0.100  V )   at %7.4r  %M", $abstime );
     $fwrite(outfile,"dnhpw    VAC    entering OCA ( -5.500  V .. 0.100  V )   at %7.4r  %M\n", $abstime );
     VAC_retc=0;
     $fclose(outfile);
   end

end // analog
endmodule // dnhpw

// Verilog-A OC Watch for device dphnw Parameters  VAC
module dphnw_ahdl(A,C);
parameter tstep_occ=100n;
inout A,C;
electrical A,C;

integer outfile;
real V_A_C;
real VAC;
integer VAC_retc;

analog begin

   $bound_step( tstep_occ );
   @(initial_step) begin
      VAC_retc=0;
   end
   V_A_C = V(A,C);

//      VAC
   VAC = V_A_C;
   if((VAC < -5.5) && (!VAC_retc))
   begin
     outfile=$fopen("./occ.err","a");
     $strobe("dphnw    VAC    leaving  OCA ( < -5.500  V )             at %7.4r  %M", $abstime );
     $fwrite(outfile,"dphnw    VAC    leaving  OCA ( < -5.500  V )             at %7.4r  %M\n", $abstime );
     VAC_retc=1;
     $fclose(outfile);
   end
   if((VAC > 0.1) && (!VAC_retc))
   begin
     outfile=$fopen("./occ.err","a");
     $strobe("dphnw    VAC    leaving  OCA ( > 0.100  V )              at %7.4r  %M", $abstime );
     $fwrite(outfile,"dphnw    VAC    leaving  OCA ( > 0.100  V )              at %7.4r  %M\n", $abstime );
     VAC_retc=1;
     $fclose(outfile);
   end
   if((VAC > -5.5) && (VAC < 0.1) && (VAC_retc))
   begin
     outfile=$fopen("./occ.err","a");
     $strobe("dphnw    VAC    entering OCA ( -5.500  V .. 0.100  V )   at %7.4r  %M", $abstime );
     $fwrite(outfile,"dphnw    VAC    entering OCA ( -5.500  V .. 0.100  V )   at %7.4r  %M\n", $abstime );
     VAC_retc=0;
     $fclose(outfile);
   end

end // analog
endmodule // dphnw

// Verilog-A OC Watch for device dipdnw Parameters  VAC
module dipdnw_ahdl(A,C);
parameter tstep_occ=100n;
inout A,C;
electrical A,C;

integer outfile;
real V_A_C;
real VAC;
integer VAC_retc;

analog begin

   $bound_step( tstep_occ );
   @(initial_step) begin
      VAC_retc=0;
   end
   V_A_C = V(A,C);

//      VAC
   VAC = V_A_C;
   if((VAC < -5.5) && (!VAC_retc))
   begin
     outfile=$fopen("./occ.err","a");
     $strobe("dipdnw   VAC    leaving  OCA ( < -5.500  V )             at %7.4r  %M", $abstime );
     $fwrite(outfile,"dipdnw   VAC    leaving  OCA ( < -5.500  V )             at %7.4r  %M\n", $abstime );
     VAC_retc=1;
     $fclose(outfile);
   end
   if((VAC > 0.1) && (!VAC_retc))
   begin
     outfile=$fopen("./occ.err","a");
     $strobe("dipdnw   VAC    leaving  OCA ( > 0.100  V )              at %7.4r  %M", $abstime );
     $fwrite(outfile,"dipdnw   VAC    leaving  OCA ( > 0.100  V )              at %7.4r  %M\n", $abstime );
     VAC_retc=1;
     $fclose(outfile);
   end
   if((VAC > -5.5) && (VAC < 0.1) && (VAC_retc))
   begin
     outfile=$fopen("./occ.err","a");
     $strobe("dipdnw   VAC    entering OCA ( -5.500  V .. 0.100  V )   at %7.4r  %M", $abstime );
     $fwrite(outfile,"dipdnw   VAC    entering OCA ( -5.500  V .. 0.100  V )   at %7.4r  %M\n", $abstime );
     VAC_retc=0;
     $fclose(outfile);
   end

end // analog
endmodule // dipdnw

// Verilog-A OC Watch for device dipdnwmv Parameters  VAC
module dipdnwmv_ahdl(A,C);
parameter tstep_occ=100n;
inout A,C;
electrical A,C;

integer outfile;
real V_A_C;
real VAC;
integer VAC_retc;

analog begin

   $bound_step( tstep_occ );
   @(initial_step) begin
      VAC_retc=0;
   end
   V_A_C = V(A,C);

//      VAC
   VAC = V_A_C;
   if((VAC < -3.6) && (!VAC_retc))
   begin
     outfile=$fopen("./occ.err","a");
     $strobe("dipdnwmv VAC    leaving  OCA ( < -3.600  V )             at %7.4r  %M", $abstime );
     $fwrite(outfile,"dipdnwmv VAC    leaving  OCA ( < -3.600  V )             at %7.4r  %M\n", $abstime );
     VAC_retc=1;
     $fclose(outfile);
   end
   if((VAC > 0.1) && (!VAC_retc))
   begin
     outfile=$fopen("./occ.err","a");
     $strobe("dipdnwmv VAC    leaving  OCA ( > 0.100  V )              at %7.4r  %M", $abstime );
     $fwrite(outfile,"dipdnwmv VAC    leaving  OCA ( > 0.100  V )              at %7.4r  %M\n", $abstime );
     VAC_retc=1;
     $fclose(outfile);
   end
   if((VAC > -3.6) && (VAC < 0.1) && (VAC_retc))
   begin
     outfile=$fopen("./occ.err","a");
     $strobe("dipdnwmv VAC    entering OCA ( -3.600  V .. 0.100  V )   at %7.4r  %M", $abstime );
     $fwrite(outfile,"dipdnwmv VAC    entering OCA ( -3.600  V .. 0.100  V )   at %7.4r  %M\n", $abstime );
     VAC_retc=0;
     $fclose(outfile);
   end

end // analog
endmodule // dipdnwmv

// Verilog-A OC Watch for device dhpw Parameters  VAC
module dhpw_ahdl(A,C);
parameter tstep_occ=100n;
inout A,C;
electrical A,C;

integer outfile;
real V_A_C;
real VAC;
integer VAC_retc;

analog begin

   $bound_step( tstep_occ );
   @(initial_step) begin
      VAC_retc=0;
   end
   V_A_C = V(A,C);

//      VAC
   VAC = V_A_C;
   if((VAC < -15) && (!VAC_retc))
   begin
     outfile=$fopen("./occ.err","a");
     $strobe("dhpw     VAC    leaving  OCA ( < -15.000  V )            at %7.4r  %M", $abstime );
     $fwrite(outfile,"dhpw     VAC    leaving  OCA ( < -15.000  V )            at %7.4r  %M\n", $abstime );
     VAC_retc=1;
     $fclose(outfile);
   end
   if((VAC > 0.1) && (!VAC_retc))
   begin
     outfile=$fopen("./occ.err","a");
     $strobe("dhpw     VAC    leaving  OCA ( > 0.100  V )              at %7.4r  %M", $abstime );
     $fwrite(outfile,"dhpw     VAC    leaving  OCA ( > 0.100  V )              at %7.4r  %M\n", $abstime );
     VAC_retc=1;
     $fclose(outfile);
   end
   if((VAC > -15) && (VAC < 0.1) && (VAC_retc))
   begin
     outfile=$fopen("./occ.err","a");
     $strobe("dhpw     VAC    entering OCA ( -15.000  V .. 0.100  V )  at %7.4r  %M", $abstime );
     $fwrite(outfile,"dhpw     VAC    entering OCA ( -15.000  V .. 0.100  V )  at %7.4r  %M\n", $abstime );
     VAC_retc=0;
     $fclose(outfile);
   end

end // analog
endmodule // dhpw

// Verilog-A OC Watch for device dhnw Parameters  VAC
module dhnw_ahdl(A,C);
parameter tstep_occ=100n;
inout A,C;
electrical A,C;

integer outfile;
real V_A_C;
real VAC;
integer VAC_retc;

analog begin

   $bound_step( tstep_occ );
   @(initial_step) begin
      VAC_retc=0;
   end
   V_A_C = V(A,C);

//      VAC
   VAC = V_A_C;
   if((VAC < -15) && (!VAC_retc))
   begin
     outfile=$fopen("./occ.err","a");
     $strobe("dhnw     VAC    leaving  OCA ( < -15.000  V )            at %7.4r  %M", $abstime );
     $fwrite(outfile,"dhnw     VAC    leaving  OCA ( < -15.000  V )            at %7.4r  %M\n", $abstime );
     VAC_retc=1;
     $fclose(outfile);
   end
   if((VAC > 0.1) && (!VAC_retc))
   begin
     outfile=$fopen("./occ.err","a");
     $strobe("dhnw     VAC    leaving  OCA ( > 0.100  V )              at %7.4r  %M", $abstime );
     $fwrite(outfile,"dhnw     VAC    leaving  OCA ( > 0.100  V )              at %7.4r  %M\n", $abstime );
     VAC_retc=1;
     $fclose(outfile);
   end
   if((VAC > -15) && (VAC < 0.1) && (VAC_retc))
   begin
     outfile=$fopen("./occ.err","a");
     $strobe("dhnw     VAC    entering OCA ( -15.000  V .. 0.100  V )  at %7.4r  %M", $abstime );
     $fwrite(outfile,"dhnw     VAC    entering OCA ( -15.000  V .. 0.100  V )  at %7.4r  %M\n", $abstime );
     VAC_retc=0;
     $fclose(outfile);
   end

end // analog
endmodule // dhnw

// Verilog-A OC Watch for device ddnwmv Parameters  VAC
module ddnwmv_ahdl(A,C);
parameter tstep_occ=100n;
inout A,C;
electrical A,C;

integer outfile;
real V_A_C;
real VAC;
integer VAC_retc;

analog begin

   $bound_step( tstep_occ );
   @(initial_step) begin
      VAC_retc=0;
   end
   V_A_C = V(A,C);

//      VAC
   VAC = V_A_C;
   if((VAC < -10) && (!VAC_retc))
   begin
     outfile=$fopen("./occ.err","a");
     $strobe("ddnwmv   VAC    leaving  OCA ( < -10.000  V )            at %7.4r  %M", $abstime );
     $fwrite(outfile,"ddnwmv   VAC    leaving  OCA ( < -10.000  V )            at %7.4r  %M\n", $abstime );
     VAC_retc=1;
     $fclose(outfile);
   end
   if((VAC > 0.1) && (!VAC_retc))
   begin
     outfile=$fopen("./occ.err","a");
     $strobe("ddnwmv   VAC    leaving  OCA ( > 0.100  V )              at %7.4r  %M", $abstime );
     $fwrite(outfile,"ddnwmv   VAC    leaving  OCA ( > 0.100  V )              at %7.4r  %M\n", $abstime );
     VAC_retc=1;
     $fclose(outfile);
   end
   if((VAC > -10) && (VAC < 0.1) && (VAC_retc))
   begin
     outfile=$fopen("./occ.err","a");
     $strobe("ddnwmv   VAC    entering OCA ( -10.000  V .. 0.100  V )  at %7.4r  %M", $abstime );
     $fwrite(outfile,"ddnwmv   VAC    entering OCA ( -10.000  V .. 0.100  V )  at %7.4r  %M\n", $abstime );
     VAC_retc=0;
     $fclose(outfile);
   end

end // analog
endmodule // ddnwmv

// Verilog-A OC Watch for device ddnw Parameters  VAC
module ddnw_ahdl(A,C);
parameter tstep_occ=100n;
inout A,C;
electrical A,C;

integer outfile;
real V_A_C;
real VAC;
integer VAC_retc;

analog begin

   $bound_step( tstep_occ );
   @(initial_step) begin
      VAC_retc=0;
   end
   V_A_C = V(A,C);

//      VAC
   VAC = V_A_C;
   if((VAC < -40) && (!VAC_retc))
   begin
     outfile=$fopen("./occ.err","a");
     $strobe("ddnw     VAC    leaving  OCA ( < -40.000  V )            at %7.4r  %M", $abstime );
     $fwrite(outfile,"ddnw     VAC    leaving  OCA ( < -40.000  V )            at %7.4r  %M\n", $abstime );
     VAC_retc=1;
     $fclose(outfile);
   end
   if((VAC > 0.1) && (!VAC_retc))
   begin
     outfile=$fopen("./occ.err","a");
     $strobe("ddnw     VAC    leaving  OCA ( > 0.100  V )              at %7.4r  %M", $abstime );
     $fwrite(outfile,"ddnw     VAC    leaving  OCA ( > 0.100  V )              at %7.4r  %M\n", $abstime );
     VAC_retc=1;
     $fclose(outfile);
   end
   if((VAC > -40) && (VAC < 0.1) && (VAC_retc))
   begin
     outfile=$fopen("./occ.err","a");
     $strobe("ddnw     VAC    entering OCA ( -40.000  V .. 0.100  V )  at %7.4r  %M", $abstime );
     $fwrite(outfile,"ddnw     VAC    entering OCA ( -40.000  V .. 0.100  V )  at %7.4r  %M\n", $abstime );
     VAC_retc=0;
     $fclose(outfile);
   end

end // analog
endmodule // ddnw

module rmOccErr;
    integer outfile;
analog begin
   @(initial_step) begin
     outfile=$fopen("./occ.err","w");

     $fwrite(outfile, "Operating condition error file \n\n");
     $fwrite(outfile,"Dev       OC-  \n");
     $fwrite(outfile,"         Para   Event        Limit                          Time        Instance\n");
     $fclose(outfile);
   end
   @(final_step) begin
     outfile=$fopen("./occ.err","a");
     $fwrite(outfile, "\n\nEnd of operating condition error file\n");
     $fclose(outfile);

   end
end
endmodule
